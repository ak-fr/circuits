* Coriolis Structural SPICE Driver
* Generated on Apr 13, 2025, 01:26
* Cell/Subckt "expmob1_r".
*
* INTERF vss
* INTERF vdd
* INTERF outputs[9]
* INTERF outputs[8]
* INTERF outputs[7]
* INTERF outputs[63]
* INTERF outputs[62]
* INTERF outputs[61]
* INTERF outputs[60]
* INTERF outputs[6]
* INTERF outputs[59]
* INTERF outputs[58]
* INTERF outputs[57]
* INTERF outputs[56]
* INTERF outputs[55]
* INTERF outputs[54]
* INTERF outputs[53]
* INTERF outputs[52]
* INTERF outputs[51]
* INTERF outputs[50]
* INTERF outputs[5]
* INTERF outputs[49]
* INTERF outputs[48]
* INTERF outputs[47]
* INTERF outputs[46]
* INTERF outputs[45]
* INTERF outputs[44]
* INTERF outputs[43]
* INTERF outputs[42]
* INTERF outputs[41]
* INTERF outputs[40]
* INTERF outputs[4]
* INTERF outputs[39]
* INTERF outputs[38]
* INTERF outputs[37]
* INTERF outputs[36]
* INTERF outputs[35]
* INTERF outputs[34]
* INTERF outputs[33]
* INTERF outputs[32]
* INTERF outputs[31]
* INTERF outputs[30]
* INTERF outputs[3]
* INTERF outputs[29]
* INTERF outputs[28]
* INTERF outputs[27]
* INTERF outputs[26]
* INTERF outputs[25]
* INTERF outputs[24]
* INTERF outputs[23]
* INTERF outputs[22]
* INTERF outputs[21]
* INTERF outputs[20]
* INTERF outputs[2]
* INTERF outputs[19]
* INTERF outputs[18]
* INTERF outputs[17]
* INTERF outputs[16]
* INTERF outputs[15]
* INTERF outputs[14]
* INTERF outputs[13]
* INTERF outputs[12]
* INTERF outputs[11]
* INTERF outputs[10]
* INTERF outputs[1]
* INTERF inputs[9]
* INTERF inputs[8]
* INTERF inputs[7]
* INTERF inputs[63]
* INTERF inputs[62]
* INTERF inputs[61]
* INTERF inputs[60]
* INTERF inputs[6]
* INTERF inputs[59]
* INTERF inputs[58]
* INTERF inputs[57]
* INTERF inputs[56]
* INTERF inputs[55]
* INTERF inputs[54]
* INTERF inputs[53]
* INTERF inputs[52]
* INTERF inputs[51]
* INTERF inputs[50]
* INTERF inputs[5]
* INTERF inputs[49]
* INTERF inputs[48]
* INTERF inputs[47]
* INTERF inputs[46]
* INTERF inputs[45]
* INTERF inputs[44]
* INTERF inputs[43]
* INTERF inputs[42]
* INTERF inputs[41]
* INTERF inputs[40]
* INTERF inputs[4]
* INTERF inputs[39]
* INTERF inputs[38]
* INTERF inputs[37]
* INTERF inputs[36]
* INTERF inputs[35]
* INTERF inputs[34]
* INTERF inputs[33]
* INTERF inputs[32]
* INTERF inputs[31]
* INTERF inputs[30]
* INTERF inputs[3]
* INTERF inputs[29]
* INTERF inputs[28]
* INTERF inputs[27]
* INTERF inputs[26]
* INTERF inputs[25]
* INTERF inputs[24]
* INTERF inputs[23]
* INTERF inputs[22]
* INTERF inputs[21]
* INTERF inputs[20]
* INTERF inputs[2]
* INTERF inputs[19]
* INTERF inputs[18]
* INTERF inputs[17]
* INTERF inputs[16]
* INTERF inputs[15]
* INTERF inputs[14]
* INTERF inputs[13]
* INTERF inputs[12]
* INTERF inputs[11]
* INTERF inputs[10]
* INTERF inputs[1]
* INTERF inputs[0]

* Terminal models (aka standard cells) used througout all the hierarchy.
.include nexor2_x0.spi
.include inv_x0.spi
.include xor2_x0.spi
.include decap_w0.spi
.include tie.spi

* Non-terminal models (part of the user's design hierarchy).

.subckt expmob1_r 0 1 2 3 4 5 6 7 8 9 10 11 12 13 14 15 16 17 18 19 20 21 22 23 24 25 26 27 28 29 30 31 32 33 34 35 36 37 38 39 40 41 42 43 44 45 46 47 48 49 50 51 52 53 54 55 56 57 58 59 60 61 62 63 64 65 66 67 68 69 70 71 72 73 74 75 76 77 78 79 80 81 82 83 84 85 86 87 88 89 90 91 92 93 94 95 96 97 98 99 100 101 102 103 104 105 106 107 108 109 110 111 112 113 114 115 116 117 118 119 120 121 122 123 124 125 126 127 128
* NET     0 = vss
* NET     1 = vdd
* NET     2 = outputs[9]
* NET     3 = outputs[8]
* NET     4 = outputs[7]
* NET     5 = outputs[63]
* NET     6 = outputs[62]
* NET     7 = outputs[61]
* NET     8 = outputs[60]
* NET     9 = outputs[6]
* NET    10 = outputs[59]
* NET    11 = outputs[58]
* NET    12 = outputs[57]
* NET    13 = outputs[56]
* NET    14 = outputs[55]
* NET    15 = outputs[54]
* NET    16 = outputs[53]
* NET    17 = outputs[52]
* NET    18 = outputs[51]
* NET    19 = outputs[50]
* NET    20 = outputs[5]
* NET    21 = outputs[49]
* NET    22 = outputs[48]
* NET    23 = outputs[47]
* NET    24 = outputs[46]
* NET    25 = outputs[45]
* NET    26 = outputs[44]
* NET    27 = outputs[43]
* NET    28 = outputs[42]
* NET    29 = outputs[41]
* NET    30 = outputs[40]
* NET    31 = outputs[4]
* NET    32 = outputs[39]
* NET    33 = outputs[38]
* NET    34 = outputs[37]
* NET    35 = outputs[36]
* NET    36 = outputs[35]
* NET    37 = outputs[34]
* NET    38 = outputs[33]
* NET    39 = outputs[32]
* NET    40 = outputs[31]
* NET    41 = outputs[30]
* NET    42 = outputs[3]
* NET    43 = outputs[29]
* NET    44 = outputs[28]
* NET    45 = outputs[27]
* NET    46 = outputs[26]
* NET    47 = outputs[25]
* NET    48 = outputs[24]
* NET    49 = outputs[23]
* NET    50 = outputs[22]
* NET    51 = outputs[21]
* NET    52 = outputs[20]
* NET    53 = outputs[2]
* NET    54 = outputs[19]
* NET    55 = outputs[18]
* NET    56 = outputs[17]
* NET    57 = outputs[16]
* NET    58 = outputs[15]
* NET    59 = outputs[14]
* NET    60 = outputs[13]
* NET    61 = outputs[12]
* NET    62 = outputs[11]
* NET    63 = outputs[10]
* NET    64 = outputs[1]
* NET    65 = inputs[9]
* NET    66 = inputs[8]
* NET    67 = inputs[7]
* NET    68 = inputs[63]
* NET    69 = inputs[62]
* NET    70 = inputs[61]
* NET    71 = inputs[60]
* NET    72 = inputs[6]
* NET    73 = inputs[59]
* NET    74 = inputs[58]
* NET    75 = inputs[57]
* NET    76 = inputs[56]
* NET    77 = inputs[55]
* NET    78 = inputs[54]
* NET    79 = inputs[53]
* NET    80 = inputs[52]
* NET    81 = inputs[51]
* NET    82 = inputs[50]
* NET    83 = inputs[5]
* NET    84 = inputs[49]
* NET    85 = inputs[48]
* NET    86 = inputs[47]
* NET    87 = inputs[46]
* NET    88 = inputs[45]
* NET    89 = inputs[44]
* NET    90 = inputs[43]
* NET    91 = inputs[42]
* NET    92 = inputs[41]
* NET    93 = inputs[40]
* NET    94 = inputs[4]
* NET    95 = inputs[39]
* NET    96 = inputs[38]
* NET    97 = inputs[37]
* NET    98 = inputs[36]
* NET    99 = inputs[35]
* NET   100 = inputs[34]
* NET   101 = inputs[33]
* NET   102 = inputs[32]
* NET   103 = inputs[31]
* NET   104 = inputs[30]
* NET   105 = inputs[3]
* NET   106 = inputs[29]
* NET   107 = inputs[28]
* NET   108 = inputs[27]
* NET   109 = inputs[26]
* NET   110 = inputs[25]
* NET   111 = inputs[24]
* NET   112 = inputs[23]
* NET   113 = inputs[22]
* NET   114 = inputs[21]
* NET   115 = inputs[20]
* NET   116 = inputs[2]
* NET   117 = inputs[19]
* NET   118 = inputs[18]
* NET   119 = inputs[17]
* NET   120 = inputs[16]
* NET   121 = inputs[15]
* NET   122 = inputs[14]
* NET   123 = inputs[13]
* NET   124 = inputs[12]
* NET   125 = inputs[11]
* NET   126 = inputs[10]
* NET   127 = inputs[1]
* NET   128 = inputs[0]
* NET   129 = genblk1_4_si_outputs_7
* NET   130 = genblk1_4_si_outputs_63
* NET   131 = genblk1_4_si_outputs_59
* NET   132 = genblk1_4_si_outputs_55
* NET   133 = genblk1_4_si_outputs_51
* NET   134 = genblk1_4_si_outputs_47
* NET   135 = genblk1_4_si_outputs_43
* NET   136 = genblk1_4_si_outputs_39
* NET   137 = genblk1_4_si_outputs_35
* NET   138 = genblk1_4_si_outputs_31
* NET   139 = genblk1_4_si_outputs_3
* NET   140 = genblk1_4_si_outputs_27
* NET   141 = genblk1_4_si_outputs_23
* NET   142 = genblk1_4_si_outputs_19
* NET   143 = genblk1_4_si_outputs_15
* NET   144 = genblk1_4_si_outputs_11
* NET   145 = genblk1_3_si_outputs_7
* NET   146 = genblk1_3_si_outputs_63
* NET   147 = genblk1_3_si_outputs_62
* NET   148 = genblk1_3_si_outputs_61
* NET   149 = genblk1_3_si_outputs_6
* NET   150 = genblk1_3_si_outputs_55
* NET   151 = genblk1_3_si_outputs_54
* NET   152 = genblk1_3_si_outputs_53
* NET   153 = genblk1_3_si_outputs_5
* NET   154 = genblk1_3_si_outputs_47
* NET   155 = genblk1_3_si_outputs_46
* NET   156 = genblk1_3_si_outputs_45
* NET   157 = genblk1_3_si_outputs_39
* NET   158 = genblk1_3_si_outputs_38
* NET   159 = genblk1_3_si_outputs_37
* NET   160 = genblk1_3_si_outputs_31
* NET   161 = genblk1_3_si_outputs_30
* NET   162 = genblk1_3_si_outputs_29
* NET   163 = genblk1_3_si_outputs_23
* NET   164 = genblk1_3_si_outputs_22
* NET   165 = genblk1_3_si_outputs_21
* NET   166 = genblk1_3_si_outputs_15
* NET   167 = genblk1_3_si_outputs_14
* NET   168 = genblk1_3_si_outputs_13
* NET   169 = genblk1_2_si_outputs_9
* NET   170 = genblk1_2_si_outputs_63
* NET   171 = genblk1_2_si_outputs_62
* NET   172 = genblk1_2_si_outputs_61
* NET   173 = genblk1_2_si_outputs_60
* NET   174 = genblk1_2_si_outputs_59
* NET   175 = genblk1_2_si_outputs_58
* NET   176 = genblk1_2_si_outputs_57
* NET   177 = genblk1_2_si_outputs_47
* NET   178 = genblk1_2_si_outputs_46
* NET   179 = genblk1_2_si_outputs_45
* NET   180 = genblk1_2_si_outputs_44
* NET   181 = genblk1_2_si_outputs_43
* NET   182 = genblk1_2_si_outputs_42
* NET   183 = genblk1_2_si_outputs_41
* NET   184 = genblk1_2_si_outputs_31
* NET   185 = genblk1_2_si_outputs_30
* NET   186 = genblk1_2_si_outputs_29
* NET   187 = genblk1_2_si_outputs_28
* NET   188 = genblk1_2_si_outputs_27
* NET   189 = genblk1_2_si_outputs_26
* NET   190 = genblk1_2_si_outputs_25
* NET   191 = genblk1_2_si_outputs_15
* NET   192 = genblk1_2_si_outputs_14
* NET   193 = genblk1_2_si_outputs_13
* NET   194 = genblk1_2_si_outputs_12
* NET   195 = genblk1_2_si_outputs_11
* NET   196 = genblk1_2_si_outputs_10
* NET   197 = genblk1_1_si_outputs_63
* NET   198 = genblk1_1_si_outputs_62
* NET   199 = genblk1_1_si_outputs_61
* NET   200 = genblk1_1_si_outputs_60
* NET   201 = genblk1_1_si_outputs_59
* NET   202 = genblk1_1_si_outputs_58
* NET   203 = genblk1_1_si_outputs_57
* NET   204 = genblk1_1_si_outputs_56
* NET   205 = genblk1_1_si_outputs_55
* NET   206 = genblk1_1_si_outputs_54
* NET   207 = genblk1_1_si_outputs_53
* NET   208 = genblk1_1_si_outputs_52
* NET   209 = genblk1_1_si_outputs_51
* NET   210 = genblk1_1_si_outputs_50
* NET   211 = genblk1_1_si_outputs_49
* NET   212 = genblk1_1_si_outputs_31
* NET   213 = genblk1_1_si_outputs_30
* NET   214 = genblk1_1_si_outputs_29
* NET   215 = genblk1_1_si_outputs_28
* NET   216 = genblk1_1_si_outputs_27
* NET   217 = genblk1_1_si_outputs_26
* NET   218 = genblk1_1_si_outputs_25
* NET   219 = genblk1_1_si_outputs_24
* NET   220 = genblk1_1_si_outputs_23
* NET   221 = genblk1_1_si_outputs_22
* NET   222 = genblk1_1_si_outputs_21
* NET   223 = genblk1_1_si_outputs_20
* NET   224 = genblk1_1_si_outputs_19
* NET   225 = genblk1_1_si_outputs_18
* NET   226 = genblk1_1_si_outputs_17
* NET   227 = genblk1_1_si_inputs_63
* NET   228 = genblk1_1_si_inputs_62
* NET   229 = genblk1_1_si_inputs_61
* NET   230 = genblk1_1_si_inputs_60
* NET   231 = genblk1_1_si_inputs_59
* NET   232 = genblk1_1_si_inputs_58
* NET   233 = genblk1_1_si_inputs_57
* NET   234 = genblk1_1_si_inputs_56
* NET   235 = genblk1_1_si_inputs_55
* NET   236 = genblk1_1_si_inputs_54
* NET   237 = genblk1_1_si_inputs_53
* NET   238 = genblk1_1_si_inputs_52
* NET   239 = genblk1_1_si_inputs_51
* NET   240 = genblk1_1_si_inputs_50
* NET   241 = genblk1_1_si_inputs_49
* NET   242 = genblk1_1_si_inputs_48
* NET   243 = genblk1_1_si_inputs_47
* NET   244 = genblk1_1_si_inputs_46
* NET   245 = genblk1_1_si_inputs_45
* NET   246 = genblk1_1_si_inputs_44
* NET   247 = genblk1_1_si_inputs_43
* NET   248 = genblk1_1_si_inputs_42
* NET   249 = genblk1_1_si_inputs_41
* NET   250 = genblk1_1_si_inputs_40
* NET   251 = genblk1_1_si_inputs_39
* NET   252 = genblk1_1_si_inputs_38
* NET   253 = genblk1_1_si_inputs_37
* NET   254 = genblk1_1_si_inputs_36
* NET   255 = genblk1_1_si_inputs_35
* NET   256 = genblk1_1_si_inputs_34
* NET   257 = genblk1_1_si_inputs_33
* NET   258 = blockagenet
* NET   259 = abc_689_new_n372
* NET   260 = abc_689_new_n371
* NET   261 = abc_689_new_n370
* NET   262 = abc_689_new_n369
* NET   263 = abc_689_new_n368
* NET   264 = abc_689_new_n366
* NET   265 = abc_689_new_n365
* NET   266 = abc_689_new_n364
* NET   267 = abc_689_new_n363
* NET   268 = abc_689_new_n362
* NET   269 = abc_689_new_n360
* NET   270 = abc_689_new_n359
* NET   271 = abc_689_new_n358
* NET   272 = abc_689_new_n357
* NET   273 = abc_689_new_n356
* NET   274 = abc_689_new_n355
* NET   275 = abc_689_new_n353
* NET   276 = abc_689_new_n352
* NET   277 = abc_689_new_n351
* NET   278 = abc_689_new_n349
* NET   279 = abc_689_new_n348
* NET   280 = abc_689_new_n347
* NET   281 = abc_689_new_n346
* NET   282 = abc_689_new_n344
* NET   283 = abc_689_new_n343
* NET   284 = abc_689_new_n342
* NET   285 = abc_689_new_n341
* NET   286 = abc_689_new_n339
* NET   287 = abc_689_new_n338
* NET   288 = abc_689_new_n337
* NET   289 = abc_689_new_n336
* NET   290 = abc_689_new_n334
* NET   291 = abc_689_new_n333
* NET   292 = abc_689_new_n332
* NET   293 = abc_689_new_n330
* NET   294 = abc_689_new_n329
* NET   295 = abc_689_new_n328
* NET   296 = abc_689_new_n327
* NET   297 = abc_689_new_n325
* NET   298 = abc_689_new_n324
* NET   299 = abc_689_new_n323
* NET   300 = abc_689_new_n321
* NET   301 = abc_689_new_n320
* NET   302 = abc_689_new_n319
* NET   303 = abc_689_new_n317
* NET   304 = abc_689_new_n316
* NET   305 = abc_689_new_n315
* NET   306 = abc_689_new_n313
* NET   307 = abc_689_new_n312
* NET   308 = abc_689_new_n311
* NET   309 = abc_689_new_n310
* NET   310 = abc_689_new_n308
* NET   311 = abc_689_new_n307
* NET   312 = abc_689_new_n306
* NET   313 = abc_689_new_n304
* NET   314 = abc_689_new_n303
* NET   315 = abc_689_new_n302
* NET   316 = abc_689_new_n300
* NET   317 = abc_689_new_n299
* NET   318 = abc_689_new_n297
* NET   319 = abc_689_new_n296
* NET   320 = abc_689_new_n295
* NET   321 = abc_689_new_n294
* NET   322 = abc_689_new_n292
* NET   323 = abc_689_new_n291
* NET   324 = abc_689_new_n290
* NET   325 = abc_689_new_n289
* NET   326 = abc_689_new_n287
* NET   327 = abc_689_new_n286
* NET   328 = abc_689_new_n285
* NET   329 = abc_689_new_n284
* NET   330 = abc_689_new_n282
* NET   331 = abc_689_new_n281
* NET   332 = abc_689_new_n280
* NET   333 = abc_689_new_n278
* NET   334 = abc_689_new_n277
* NET   335 = abc_689_new_n276
* NET   336 = abc_689_new_n275
* NET   337 = abc_689_new_n273
* NET   338 = abc_689_new_n272
* NET   339 = abc_689_new_n271
* NET   340 = abc_689_new_n269
* NET   341 = abc_689_new_n268
* NET   342 = abc_689_new_n267
* NET   343 = abc_689_new_n265
* NET   344 = abc_689_new_n264
* NET   345 = abc_689_new_n262
* NET   346 = abc_689_new_n261
* NET   347 = abc_689_new_n260
* NET   348 = abc_689_new_n258
* NET   349 = abc_689_new_n257
* NET   350 = abc_689_new_n255
* NET   351 = abc_689_new_n254
* NET   352 = abc_689_new_n252
* NET   353 = abc_689_new_n251
* NET   354 = abc_689_new_n249
* NET   355 = abc_689_new_n248
* NET   356 = abc_689_new_n246
* NET   357 = abc_689_new_n245
* NET   358 = abc_689_new_n243
* NET   359 = abc_689_new_n241
* NET   360 = abc_689_new_n239
* NET   361 = abc_689_new_n238
* NET   362 = abc_689_new_n237
* NET   363 = abc_689_new_n236
* NET   364 = abc_689_new_n234
* NET   365 = abc_689_new_n233
* NET   366 = abc_689_new_n232
* NET   367 = abc_689_new_n230
* NET   368 = abc_689_new_n229
* NET   369 = abc_689_new_n228
* NET   370 = abc_689_new_n226
* NET   371 = abc_689_new_n225
* NET   372 = abc_689_new_n224
* NET   373 = abc_689_new_n223
* NET   374 = abc_689_new_n221
* NET   375 = abc_689_new_n220
* NET   376 = abc_689_new_n219
* NET   377 = abc_689_new_n218
* NET   378 = abc_689_new_n216
* NET   379 = abc_689_new_n215
* NET   380 = abc_689_new_n214
* NET   381 = abc_689_new_n212
* NET   382 = abc_689_new_n211
* NET   383 = abc_689_new_n210
* NET   384 = abc_689_new_n208
* NET   385 = abc_689_new_n207
* NET   386 = abc_689_new_n206
* NET   387 = abc_689_new_n204
* NET   388 = abc_689_new_n203
* NET   389 = abc_689_new_n202
* NET   390 = abc_689_new_n200
* NET   391 = abc_689_new_n199
* NET   392 = abc_689_new_n198
* NET   393 = abc_689_new_n197
* NET   394 = abc_689_new_n195
* NET   395 = abc_689_new_n194
* NET   396 = abc_689_new_n193
* NET   397 = abc_689_new_n192
* NET   398 = abc_689_new_n190
* NET   399 = abc_689_new_n189
* NET   400 = abc_689_new_n188
* NET   401 = abc_689_new_n186
* NET   402 = abc_689_new_n185
* NET   403 = abc_689_new_n183
* NET   404 = abc_689_new_n182
* NET   405 = abc_689_new_n180
* NET   406 = abc_689_new_n179
* NET   407 = abc_689_new_n177
* NET   408 = abc_689_new_n175
* NET   409 = abc_689_new_n174
* NET   410 = abc_689_new_n173
* NET   411 = abc_689_new_n171
* NET   412 = abc_689_new_n170
* NET   413 = abc_689_new_n169
* NET   414 = abc_689_new_n168
* NET   415 = abc_689_new_n166
* NET   416 = abc_689_new_n165
* NET   417 = abc_689_new_n164
* NET   418 = abc_689_new_n162
* NET   419 = abc_689_new_n161
* NET   420 = abc_689_new_n160
* NET   421 = abc_689_new_n158
* NET   422 = abc_689_new_n157
* NET   423 = abc_689_new_n156
* NET   424 = abc_689_new_n154
* NET   425 = abc_689_new_n153
* NET   426 = abc_689_new_n152
* NET   427 = abc_689_new_n150
* NET   428 = abc_689_new_n149
* NET   429 = abc_689_new_n147
* NET   430 = abc_689_new_n145
* NET   431 = abc_689_new_n144
* NET   432 = abc_689_new_n143
* NET   433 = abc_689_new_n141
* NET   434 = abc_689_new_n140
* NET   435 = abc_689_new_n138
* NET   436 = abc_689_new_n137
* NET   437 = abc_689_new_n135
* NET   438 = abc_689_new_n133
* NET   439 = abc_689_new_n132
* NET   440 = abc_689_new_n130
* NET   441 = abc_689_new_n128

xsubckt_159_nexor2_x0 1 0 328 330 326 nexor2_x0
xsubckt_114_inv_x0 1 0 359 64 inv_x0
xsubckt_5_nexor2_x0 1 0 439 57 438 nexor2_x0
xsubckt_168_nexor2_x0 1 0 320 327 319 nexor2_x0
xsubckt_172_xor2_x0 1 0 101 127 316 xor2_x0
xsubckt_92_nexor2_x0 1 0 376 378 375 nexor2_x0
xsubckt_83_nexor2_x0 1 0 383 385 382 nexor2_x0
xsubckt_51_xor2_x0 1 0 72 94 406 xor2_x0
xsubckt_79_xor2_x0 1 0 100 116 385 xor2_x0
xsubckt_198_nexor2_x0 1 0 297 415 25 nexor2_x0
xsubckt_221_nexor2_x0 1 0 279 282 278 nexor2_x0
xsubckt_230_nexor2_x0 1 0 273 287 271 nexor2_x0
xsubckt_140_xor2_x0 1 0 105 117 341 xor2_x0
xsubckt_129_xor2_x0 1 0 123 65 349 xor2_x0
xsubckt_26_nexor2_x0 1 0 426 441 424 nexor2_x0
xsubckt_74_nexor2_x0 1 0 122 104 389 nexor2_x0
xsubckt_189_nexor2_x0 1 0 305 316 303 nexor2_x0
xsubckt_212_nexor2_x0 1 0 286 370 18 nexor2_x0
xsubckt_17_nexor2_x0 1 0 431 438 430 nexor2_x0
xsubckt_175_xor2_x0 1 0 99 105 314 xor2_x0
xsubckt_203_nexor2_x0 1 0 293 374 23 nexor2_x0
xsubckt_47_nexor2_x0 1 0 409 412 408 nexor2_x0
xsubckt_233_nexor2_x0 1 0 270 11 10 nexor2_x0
xsubckt_242_nexor2_x0 1 0 262 280 261 nexor2_x0
xsubckt_86_nexor2_x0 1 0 91 126 380 nexor2_x0
xsubckt_38_nexor2_x0 1 0 416 30 415 nexor2_x0
xsubckt_224_nexor2_x0 1 0 277 305 276 nexor2_x0
xsubckt_31_inv_x0 1 0 421 44 inv_x0
xsubckt_29_nexor2_x0 1 0 423 426 422 nexor2_x0
xsubckt_77_nexor2_x0 1 0 387 44 41 nexor2_x0
xsubckt_215_nexor2_x0 1 0 285 339 283 nexor2_x0
xsubckt_39_inv_x0 1 0 415 26 inv_x0
xsubckt_35_inv_x0 1 0 418 35 inv_x0
xsubckt_61_xor2_x0 1 0 116 118 399 xor2_x0
xsubckt_206_nexor2_x0 1 0 292 344 290 nexor2_x0
xsubckt_4_xor2_x0 1 0 85 102 439 xor2_x0
xsubckt_57_xor2_x0 1 0 122 72 402 xor2_x0
xsubckt_59_nexor2_x0 1 0 401 427 59 nexor2_x0
xsubckt_236_nexor2_x0 1 0 267 283 266 nexor2_x0
xsubckt_245_nexor2_x0 1 0 259 6 5 nexor2_x0
xsubckt_130_nexor2_x0 1 0 349 356 348 nexor2_x0
xsubckt_121_nexor2_x0 1 0 355 357 354 nexor2_x0
xsubckt_98_nexor2_x0 1 0 372 438 370 nexor2_x0
xsubckt_89_nexor2_x0 1 0 379 433 28 nexor2_x0
xsubckt_227_nexor2_x0 1 0 73 108 274 nexor2_x0
xsubckt_112_nexor2_x0 1 0 360 8 6 nexor2_x0
xsubckt_63_inv_x0 1 0 398 55 inv_x0
xsubckt_160_nexor2_x0 1 0 326 390 45 nexor2_x0
xsubckt_151_nexor2_x0 1 0 333 394 49 nexor2_x0
xsubckt_103_nexor2_x0 1 0 367 411 15 nexor2_x0
xsubckt_25_xor2_x0 1 0 94 115 425 xor2_x0
xsubckt_68_inv_x0 1 0 394 50 inv_x0
xsubckt_209_nexor2_x0 1 0 289 341 288 nexor2_x0
xsubckt_142_nexor2_x0 1 0 340 398 54 nexor2_x0
xsubckt_190_nexor2_x0 1 0 304 30 29 nexor2_x0
xsubckt_213_xor2_x0 1 0 79 97 285 xor2_x0
xsubckt_239_nexor2_x0 1 0 264 8 7 nexor2_x0
xsubckt_133_nexor2_x0 1 0 347 351 346 nexor2_x0
xsubckt_99_inv_x0 1 0 370 19 inv_x0
xsubckt_94_inv_x0 1 0 374 24 inv_x0
xsubckt_28_xor2_x0 1 0 124 107 423 xor2_x0
xsubckt_163_nexor2_x0 1 0 324 331 323 nexor2_x0
xsubckt_156_xor2_x0 1 0 125 108 329 xor2_x0
xsubckt_154_nexor2_x0 1 0 332 344 330 nexor2_x0
xsubckt_106_nexor2_x0 1 0 365 371 364 nexor2_x0
xsubckt_0_nexor2_x0 1 0 128 120 441 nexor2_x0
xsubckt_145_nexor2_x0 1 0 339 344 337 nexor2_x0
xsubckt_30_nexor2_x0 1 0 422 48 421 nexor2_x0
xsubckt_193_nexor2_x0 1 0 301 303 300 nexor2_x0
xsubckt_136_nexor2_x0 1 0 127 119 344 nexor2_x0
xsubckt_127_nexor2_x0 1 0 351 352 350 nexor2_x0
xsubckt_124_xor2_x0 1 0 65 127 352 xor2_x0
xsubckt_3_inv_x0 1 0 440 39 inv_x0
xsubckt_1_inv_x0 1 0 441 57 inv_x0
xsubckt_12_nexor2_x0 1 0 93 66 434 nexor2_x0
xsubckt_184_nexor2_x0 1 0 309 314 307 nexor2_x0
xsubckt_8_inv_x0 1 0 437 3 inv_x0
xsubckt_6_inv_x0 1 0 438 22 inv_x0
xsubckt_60_nexor2_x0 1 0 116 118 400 nexor2_x0
xsubckt_166_nexor2_x0 1 0 121 103 321 nexor2_x0
xsubckt_157_nexor2_x0 1 0 329 341 328 nexor2_x0
xsubckt_109_nexor2_x0 1 0 363 389 362 nexor2_x0
xsubckt_90_nexor2_x0 1 0 87 122 377 nexor2_x0
xsubckt_42_nexor2_x0 1 0 414 426 412 nexor2_x0
xfeed_10 1 0 decap_w0
xfeed_11 1 0 decap_w0
xfeed_12 1 0 tie
xfeed_13 1 0 tie
xfeed_14 1 0 tie
xfeed_15 1 0 tie
xfeed_16 1 0 decap_w0
xfeed_17 1 0 decap_w0
xfeed_18 1 0 decap_w0
xfeed_19 1 0 decap_w0
xsubckt_196_nexor2_x0 1 0 299 312 298 nexor2_x0
xsubckt_139_nexor2_x0 1 0 105 117 342 nexor2_x0
xsubckt_24_nexor2_x0 1 0 94 115 426 nexor2_x0
xsubckt_15_nexor2_x0 1 0 76 111 432 nexor2_x0
xsubckt_72_nexor2_x0 1 0 392 435 390 nexor2_x0
xsubckt_187_nexor2_x0 1 0 92 65 305 nexor2_x0
xsubckt_201_nexor2_x0 1 0 295 301 294 nexor2_x0
xsubckt_210_nexor2_x0 1 0 289 342 287 nexor2_x0
xfeed_20 1 0 decap_w0
xfeed_21 1 0 decap_w0
xfeed_22 1 0 decap_w0
xfeed_23 1 0 decap_w0
xfeed_24 1 0 decap_w0
xfeed_25 1 0 decap_w0
xfeed_26 1 0 tie
xfeed_27 1 0 tie
xfeed_28 1 0 tie
xfeed_29 1 0 decap_w0
xsubckt_54_nexor2_x0 1 0 126 116 404 nexor2_x0
xsubckt_169_nexor2_x0 1 0 319 322 318 nexor2_x0
xsubckt_178_nexor2_x0 1 0 97 83 312 nexor2_x0
xsubckt_93_nexor2_x0 1 0 375 415 374 nexor2_x0
xsubckt_45_nexor2_x0 1 0 71 107 410 nexor2_x0
xsubckt_231_nexor2_x0 1 0 271 275 270 nexor2_x0
xfeed_30 1 0 decap_w0
xfeed_31 1 0 decap_w0
xfeed_32 1 0 tie
xfeed_33 1 0 tie
xfeed_34 1 0 decap_w0
xfeed_35 1 0 decap_w0
xfeed_36 1 0 decap_w0
xfeed_37 1 0 tie
xfeed_38 1 0 tie
xfeed_39 1 0 decap_w0
xsubckt_84_nexor2_x0 1 0 383 386 381 nexor2_x0
xsubckt_36_nexor2_x0 1 0 89 124 417 nexor2_x0
xsubckt_199_nexor2_x0 1 0 86 121 296 nexor2_x0
xsubckt_222_nexor2_x0 1 0 278 15 14 nexor2_x0
xsubckt_11_inv_x0 1 0 435 48 inv_x0
xsubckt_14_inv_x0 1 0 433 30 inv_x0
xsubckt_75_nexor2_x0 1 0 389 396 388 nexor2_x0
xsubckt_240_xor2_x0 1 0 68 86 263 xor2_x0
xfeed_40 1 0 decap_w0
xfeed_41 1 0 tie
xfeed_42 1 0 decap_w0
xfeed_43 1 0 decap_w0
xfeed_44 1 0 tie
xfeed_45 1 0 tie
xfeed_46 1 0 tie
xsubckt_137_xor2_x0 1 0 127 119 343 xor2_x0
xsubckt_18_inv_x0 1 0 430 13 inv_x0
xsubckt_66_nexor2_x0 1 0 397 399 395 nexor2_x0
xsubckt_243_nexor2_x0 1 0 261 266 260 nexor2_x0
xfeed_47 1 0 decap_w0
xfeed_48 1 0 decap_w0
xfeed_49 1 0 decap_w0
xsubckt_96_nexor2_x0 1 0 373 399 372 nexor2_x0
xsubckt_48_nexor2_x0 1 0 408 430 8 nexor2_x0
xfeed_50 1 0 decap_w0
xfeed_51 1 0 decap_w0
xfeed_52 1 0 decap_w0
xfeed_53 1 0 decap_w0
xfeed_109 1 0 decap_w0
xfeed_108 1 0 decap_w0
xfeed_107 1 0 decap_w0
xfeed_106 1 0 tie
xfeed_105 1 0 tie
xfeed_104 1 0 decap_w0
xfeed_103 1 0 decap_w0
xfeed_102 1 0 decap_w0
xfeed_101 1 0 decap_w0
xfeed_100 1 0 tie
xfeed_59 1 0 decap_w0
xsubckt_144_xor2_x0 1 0 83 114 338 xor2_x0
xsubckt_87_nexor2_x0 1 0 380 385 379 nexor2_x0
xsubckt_183_xor2_x0 1 0 95 67 308 xor2_x0
xsubckt_225_nexor2_x0 1 0 276 290 275 nexor2_x0
xfeed_54 1 0 decap_w0
xfeed_55 1 0 tie
xfeed_56 1 0 decap_w0
xfeed_57 1 0 tie
xfeed_58 1 0 decap_w0
xfeed_60 1 0 tie
xsubckt_110_nexor2_x0 1 0 362 365 361 nexor2_x0
xsubckt_44_inv_x0 1 0 411 17 inv_x0
xsubckt_78_nexor2_x0 1 0 100 116 386 nexor2_x0
xsubckt_181_inv_x0 1 0 310 34 inv_x0
xsubckt_204_xor2_x0 1 0 84 101 292 xor2_x0
xsubckt_207_nexor2_x0 1 0 291 22 21 nexor2_x0
xsubckt_216_nexor2_x0 1 0 284 290 282 nexor2_x0
xfeed_119 1 0 decap_w0
xfeed_118 1 0 decap_w0
xfeed_117 1 0 tie
xfeed_116 1 0 tie
xfeed_115 1 0 tie
xfeed_114 1 0 tie
xfeed_113 1 0 decap_w0
xfeed_112 1 0 decap_w0
xfeed_111 1 0 decap_w0
xfeed_110 1 0 decap_w0
xfeed_69 1 0 decap_w0
xfeed_68 1 0 tie
xfeed_67 1 0 tie
xfeed_66 1 0 tie
xfeed_65 1 0 decap_w0
xfeed_64 1 0 tie
xfeed_63 1 0 tie
xfeed_62 1 0 tie
xfeed_61 1 0 tie
xsubckt_101_nexor2_x0 1 0 369 397 368 nexor2_x0
xsubckt_131_nexor2_x0 1 0 348 61 60 nexor2_x0
xsubckt_237_nexor2_x0 1 0 267 284 265 nexor2_x0
xfeed_129 1 0 decap_w0
xfeed_128 1 0 decap_w0
xfeed_127 1 0 tie
xfeed_126 1 0 tie
xfeed_125 1 0 decap_w0
xfeed_124 1 0 decap_w0
xfeed_123 1 0 decap_w0
xfeed_122 1 0 tie
xfeed_121 1 0 decap_w0
xfeed_120 1 0 decap_w0
xfeed_79 1 0 tie
xfeed_78 1 0 tie
xfeed_77 1 0 tie
xfeed_76 1 0 decap_w0
xfeed_75 1 0 tie
xfeed_74 1 0 decap_w0
xfeed_73 1 0 tie
xfeed_72 1 0 decap_w0
xfeed_71 1 0 tie
xfeed_70 1 0 tie
xsubckt_122_nexor2_x0 1 0 354 405 4 nexor2_x0
xsubckt_108_xor2_x0 1 0 69 87 363 xor2_x0
xsubckt_73_inv_x0 1 0 390 46 inv_x0
xsubckt_170_nexor2_x0 1 0 318 41 40 nexor2_x0
xsubckt_219_nexor2_x0 1 0 281 335 280 nexor2_x0
xsubckt_228_nexor2_x0 1 0 274 302 273 nexor2_x0
xsubckt_113_nexor2_x0 1 0 127 128 359 nexor2_x0
xsubckt_65_xor2_x0 1 0 72 113 396 xor2_x0
xsubckt_161_nexor2_x0 1 0 123 106 325 nexor2_x0
xfeed_135 1 0 tie
xfeed_134 1 0 decap_w0
xfeed_133 1 0 decap_w0
xfeed_132 1 0 decap_w0
xfeed_131 1 0 decap_w0
xfeed_130 1 0 tie
xfeed_89 1 0 decap_w0
xfeed_88 1 0 decap_w0
xfeed_87 1 0 decap_w0
xfeed_86 1 0 decap_w0
xfeed_85 1 0 decap_w0
xfeed_84 1 0 tie
xfeed_83 1 0 tie
xfeed_82 1 0 tie
xfeed_81 1 0 decap_w0
xfeed_80 1 0 decap_w0
xsubckt_115_xor2_x0 1 0 105 116 358 xor2_x0
xsubckt_104_nexor2_x0 1 0 74 109 366 nexor2_x0
xsubckt_143_nexor2_x0 1 0 83 114 339 nexor2_x0
xsubckt_134_nexor2_x0 1 0 346 348 345 nexor2_x0
xsubckt_33_xor2_x0 1 0 98 94 419 xor2_x0
xsubckt_191_nexor2_x0 1 0 90 125 302 nexor2_x0
xfeed_99 1 0 tie
xfeed_98 1 0 tie
xfeed_97 1 0 tie
xfeed_96 1 0 tie
xfeed_95 1 0 decap_w0
xfeed_94 1 0 decap_w0
xfeed_93 1 0 tie
xfeed_92 1 0 tie
xfeed_91 1 0 decap_w0
xfeed_90 1 0 decap_w0
xsubckt_125_nexor2_x0 1 0 353 3 2 nexor2_x0
xsubckt_10_nexor2_x0 1 0 436 57 435 nexor2_x0
xsubckt_173_nexor2_x0 1 0 317 39 38 nexor2_x0
xsubckt_182_nexor2_x0 1 0 95 67 309 nexor2_x0
xsubckt_116_nexor2_x0 1 0 358 359 42 nexor2_x0
xsubckt_107_nexor2_x0 1 0 364 430 11 nexor2_x0
xsubckt_40_xor2_x0 1 0 80 98 414 xor2_x0
xsubckt_164_nexor2_x0 1 0 324 330 322 nexor2_x0
xsubckt_155_nexor2_x0 1 0 331 48 47 nexor2_x0
xsubckt_118_xor2_x0 1 0 83 127 356 xor2_x0
xsubckt_146_nexor2_x0 1 0 337 52 51 nexor2_x0
xsubckt_22_nexor2_x0 1 0 428 31 427 nexor2_x0
xsubckt_194_nexor2_x0 1 0 300 28 27 nexor2_x0
xsubckt_128_nexor2_x0 1 0 350 403 62 nexor2_x0
xsubckt_13_nexor2_x0 1 0 434 440 433 nexor2_x0
xsubckt_70_nexor2_x0 1 0 393 399 392 nexor2_x0
xsubckt_176_nexor2_x0 1 0 315 316 313 nexor2_x0
xsubckt_185_nexor2_x0 1 0 307 381 306 nexor2_x0
xsubckt_119_nexor2_x0 1 0 357 31 20 nexor2_x0
xsubckt_52_nexor2_x0 1 0 406 53 405 nexor2_x0
xsubckt_167_nexor2_x0 1 0 321 335 320 nexor2_x0
xsubckt_158_nexor2_x0 1 0 329 342 327 nexor2_x0
xsubckt_149_nexor2_x0 1 0 336 341 334 nexor2_x0
xsubckt_91_nexor2_x0 1 0 377 383 376 nexor2_x0
xsubckt_34_nexor2_x0 1 0 420 440 418 nexor2_x0
xsubckt_43_nexor2_x0 1 0 413 438 411 nexor2_x0
xsubckt_82_nexor2_x0 1 0 96 72 383 nexor2_x0
xsubckt_197_nexor2_x0 1 0 298 303 297 nexor2_x0
xsubckt_211_nexor2_x0 1 0 288 290 286 nexor2_x0
xsubckt_220_nexor2_x0 1 0 280 287 279 nexor2_x0
xsubckt_100_xor2_x0 1 0 78 96 369 xor2_x0
xsubckt_16_nexor2_x0 1 0 432 434 431 nexor2_x0
xsubckt_64_nexor2_x0 1 0 72 113 397 nexor2_x0
xsubckt_179_nexor2_x0 1 0 312 317 311 nexor2_x0
xsubckt_188_nexor2_x0 1 0 305 317 304 nexor2_x0
xsubckt_202_nexor2_x0 1 0 294 297 293 nexor2_x0
xsubckt_55_nexor2_x0 1 0 404 437 403 nexor2_x0
xsubckt_234_xor2_x0 1 0 70 88 268 xor2_x0
xsubckt_241_nexor2_x0 1 0 263 321 262 nexor2_x0
xsubckt_37_nexor2_x0 1 0 417 419 416 nexor2_x0
xsubckt_7_nexor2_x0 1 0 66 128 437 nexor2_x0
xsubckt_46_nexor2_x0 1 0 410 417 409 nexor2_x0
xsubckt_232_nexor2_x0 1 0 272 275 269 nexor2_x0
xsubckt_85_nexor2_x0 1 0 382 418 33 nexor2_x0
xsubckt_20_inv_x0 1 0 429 31 inv_x0
xsubckt_76_nexor2_x0 1 0 388 391 387 nexor2_x0
xsubckt_214_nexor2_x0 1 0 285 338 284 nexor2_x0
xsubckt_223_nexor2_x0 1 0 75 110 277 nexor2_x0
xsubckt_23_inv_x0 1 0 427 61 inv_x0
xsubckt_19_nexor2_x0 1 0 94 128 429 nexor2_x0
xsubckt_67_nexor2_x0 1 0 395 52 394 nexor2_x0
xsubckt_205_nexor2_x0 1 0 292 343 291 nexor2_x0
xfeed_0 1 0 tie
xsubckt_27_inv_x0 1 0 424 52 inv_x0
xsubckt_21_xor2_x0 1 0 124 66 428 xor2_x0
xsubckt_58_nexor2_x0 1 0 402 404 401 nexor2_x0
xsubckt_244_nexor2_x0 1 0 260 269 259 nexor2_x0
xfeed_1 1 0 decap_w0
xfeed_2 1 0 tie
xfeed_3 1 0 decap_w0
xfeed_4 1 0 tie
xfeed_5 1 0 decap_w0
xfeed_6 1 0 decap_w0
xfeed_7 1 0 decap_w0
xfeed_8 1 0 decap_w0
xfeed_9 1 0 decap_w0
xsubckt_97_nexor2_x0 1 0 373 400 371 nexor2_x0
xsubckt_95_xor2_x0 1 0 82 100 373 xor2_x0
xsubckt_49_nexor2_x0 1 0 116 128 407 nexor2_x0
xsubckt_226_nexor2_x0 1 0 275 430 12 nexor2_x0
xsubckt_235_nexor2_x0 1 0 268 325 267 nexor2_x0
xsubckt_88_nexor2_x0 1 0 380 386 378 nexor2_x0
xsubckt_50_inv_x0 1 0 407 53 inv_x0
xsubckt_53_inv_x0 1 0 405 9 inv_x0
xsubckt_217_nexor2_x0 1 0 282 411 16 nexor2_x0
xsubckt_111_nexor2_x0 1 0 361 367 360 nexor2_x0
xsubckt_102_nexor2_x0 1 0 368 372 367 nexor2_x0
xsubckt_56_inv_x0 1 0 403 63 inv_x0
xsubckt_152_xor2_x0 1 0 65 110 332 xor2_x0
xsubckt_150_nexor2_x0 1 0 334 337 333 nexor2_x0
xsubckt_141_nexor2_x0 1 0 342 343 340 nexor2_x0
xsubckt_148_xor2_x0 1 0 67 112 335 xor2_x0
xsubckt_132_nexor2_x0 1 0 121 67 347 nexor2_x0
xsubckt_180_nexor2_x0 1 0 311 418 310 nexor2_x0
xsubckt_229_nexor2_x0 1 0 273 288 272 nexor2_x0
xsubckt_238_nexor2_x0 1 0 265 275 264 nexor2_x0
xspare_feed_10 1 0 decap_w0
xspare_feed_11 1 0 tie
xspare_feed_12 1 0 tie
xspare_feed_13 1 0 decap_w0
xsubckt_123_nexor2_x0 1 0 65 127 353 nexor2_x0
xsubckt_120_xor2_x0 1 0 67 105 355 xor2_x0
xsubckt_81_inv_x0 1 0 384 37 inv_x0
xsubckt_171_nexor2_x0 1 0 101 127 317 nexor2_x0
xsubckt_208_xor2_x0 1 0 81 99 289 xor2_x0
xspare_feed_14 1 0 tie
xspare_feed_15 1 0 tie
xsubckt_105_nexor2_x0 1 0 366 380 365 nexor2_x0
xsubckt_162_nexor2_x0 1 0 325 338 324 nexor2_x0
xsubckt_153_nexor2_x0 1 0 332 343 331 nexor2_x0
xsubckt_9_xor2_x0 1 0 66 111 436 xor2_x0
xsubckt_135_nexor2_x0 1 0 345 59 58 nexor2_x0
xsubckt_192_nexor2_x0 1 0 302 314 301 nexor2_x0
xspare_feed_0 1 0 tie
xspare_feed_1 1 0 tie
xspare_feed_2 1 0 tie
xspare_feed_3 1 0 tie
xspare_feed_4 1 0 decap_w0
xspare_feed_5 1 0 tie
xspare_feed_6 1 0 tie
xspare_feed_7 1 0 decap_w0
xspare_feed_8 1 0 tie
xspare_feed_9 1 0 tie
xsubckt_126_nexor2_x0 1 0 125 105 351 nexor2_x0
xsubckt_117_nexor2_x0 1 0 83 127 357 nexor2_x0
xsubckt_69_xor2_x0 1 0 126 109 393 xor2_x0
xsubckt_174_nexor2_x0 1 0 99 105 315 nexor2_x0
xsubckt_2_nexor2_x0 1 0 102 128 440 nexor2_x0
xsubckt_41_nexor2_x0 1 0 414 425 413 nexor2_x0
xsubckt_165_nexor2_x0 1 0 323 421 43 nexor2_x0
xsubckt_218_xor2_x0 1 0 77 95 281 xor2_x0
xsubckt_147_nexor2_x0 1 0 67 112 336 nexor2_x0
xsubckt_32_nexor2_x0 1 0 98 94 420 nexor2_x0
xsubckt_138_nexor2_x0 1 0 344 57 56 nexor2_x0
xsubckt_71_nexor2_x0 1 0 393 400 391 nexor2_x0
xsubckt_80_nexor2_x0 1 0 386 440 384 nexor2_x0
xsubckt_186_nexor2_x0 1 0 306 310 32 nexor2_x0
xsubckt_195_nexor2_x0 1 0 88 123 299 nexor2_x0
xsubckt_62_nexor2_x0 1 0 400 441 398 nexor2_x0
xsubckt_177_nexor2_x0 1 0 313 384 36 nexor2_x0
xsubckt_200_nexor2_x0 1 0 296 308 295 nexor2_x0
.ends expmob1_r
