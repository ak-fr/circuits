* Coriolis Structural SPICE Driver
* Generated on Apr 15, 2025, 16:21
* Cell/Subckt "expmob2".
*
* INTERF vss
* INTERF vdd
* INTERF outputs[9]
* INTERF outputs[8]
* INTERF outputs[7]
* INTERF outputs[63]
* INTERF outputs[62]
* INTERF outputs[61]
* INTERF outputs[60]
* INTERF outputs[6]
* INTERF outputs[59]
* INTERF outputs[58]
* INTERF outputs[57]
* INTERF outputs[56]
* INTERF outputs[55]
* INTERF outputs[54]
* INTERF outputs[53]
* INTERF outputs[52]
* INTERF outputs[51]
* INTERF outputs[50]
* INTERF outputs[5]
* INTERF outputs[49]
* INTERF outputs[48]
* INTERF outputs[47]
* INTERF outputs[46]
* INTERF outputs[45]
* INTERF outputs[44]
* INTERF outputs[43]
* INTERF outputs[42]
* INTERF outputs[41]
* INTERF outputs[40]
* INTERF outputs[4]
* INTERF outputs[39]
* INTERF outputs[38]
* INTERF outputs[37]
* INTERF outputs[36]
* INTERF outputs[35]
* INTERF outputs[34]
* INTERF outputs[33]
* INTERF outputs[32]
* INTERF outputs[31]
* INTERF outputs[30]
* INTERF outputs[3]
* INTERF outputs[29]
* INTERF outputs[28]
* INTERF outputs[27]
* INTERF outputs[26]
* INTERF outputs[25]
* INTERF outputs[24]
* INTERF outputs[23]
* INTERF outputs[22]
* INTERF outputs[21]
* INTERF outputs[20]
* INTERF outputs[2]
* INTERF outputs[19]
* INTERF outputs[18]
* INTERF outputs[17]
* INTERF outputs[16]
* INTERF outputs[15]
* INTERF outputs[14]
* INTERF outputs[13]
* INTERF outputs[12]
* INTERF outputs[11]
* INTERF outputs[10]
* INTERF outputs[1]
* INTERF outputs[0]
* INTERF inputs[9]
* INTERF inputs[8]
* INTERF inputs[7]
* INTERF inputs[63]
* INTERF inputs[62]
* INTERF inputs[61]
* INTERF inputs[60]
* INTERF inputs[6]
* INTERF inputs[59]
* INTERF inputs[58]
* INTERF inputs[57]
* INTERF inputs[56]
* INTERF inputs[55]
* INTERF inputs[54]
* INTERF inputs[53]
* INTERF inputs[52]
* INTERF inputs[51]
* INTERF inputs[50]
* INTERF inputs[5]
* INTERF inputs[49]
* INTERF inputs[48]
* INTERF inputs[47]
* INTERF inputs[46]
* INTERF inputs[45]
* INTERF inputs[44]
* INTERF inputs[43]
* INTERF inputs[42]
* INTERF inputs[41]
* INTERF inputs[40]
* INTERF inputs[4]
* INTERF inputs[39]
* INTERF inputs[38]
* INTERF inputs[37]
* INTERF inputs[36]
* INTERF inputs[35]
* INTERF inputs[34]
* INTERF inputs[33]
* INTERF inputs[32]
* INTERF inputs[31]
* INTERF inputs[30]
* INTERF inputs[3]
* INTERF inputs[29]
* INTERF inputs[28]
* INTERF inputs[27]
* INTERF inputs[26]
* INTERF inputs[25]
* INTERF inputs[24]
* INTERF inputs[23]
* INTERF inputs[22]
* INTERF inputs[21]
* INTERF inputs[20]
* INTERF inputs[2]
* INTERF inputs[19]
* INTERF inputs[18]
* INTERF inputs[17]
* INTERF inputs[16]
* INTERF inputs[15]
* INTERF inputs[14]
* INTERF inputs[13]
* INTERF inputs[12]
* INTERF inputs[11]
* INTERF inputs[10]
* INTERF inputs[1]
* INTERF inputs[0]
* INTERF clk

* Terminal models (aka standard cells) used througout all the hierarchy.
.include dff_x1.spi
.include nor3_x0.spi
.include inv_x0.spi
.include and2_x1.spi
.include and4_x1.spi
.include nexor2_x0.spi
.include or3_x1.spi
.include nand3_x0.spi
.include nor2_x0.spi
.include or2_x1.spi
.include nand2_x0.spi
.include or21nand_x0.spi
.include and3_x1.spi
.include mux2_x1.spi
.include xor2_x0.spi
.include nor4_x0.spi
.include and21nor_x0.spi
.include nand4_x0.spi
.include one_x1.spi

* Non-terminal models (part of the user's design hierarchy).

.subckt expmob2 0 1 2 3 4 5 6 7 8 9 10 11 12 13 14 15 16 17 18 19 20 21 22 23 24 25 26 27 28 29 30 31 32 33 34 35 36 37 38 39 40 41 42 43 44 45 46 47 48 49 50 51 52 53 54 55 56 57 58 59 60 61 62 63 64 65 131 132 133 134 135 136 137 138 139 140 141 142 143 144 145 146 147 148 149 150 151 152 153 154 155 156 157 158 159 160 161 162 163 164 165 166 167 168 169 170 171 172 173 174 175 176 177 178 179 180 181 182 183 184 185 186 187 188 189 190 191 192 193 194 196
* NET     0 = vss
* NET     1 = vdd
* NET     2 = outputs[9]
* NET     3 = outputs[8]
* NET     4 = outputs[7]
* NET     5 = outputs[63]
* NET     6 = outputs[62]
* NET     7 = outputs[61]
* NET     8 = outputs[60]
* NET     9 = outputs[6]
* NET    10 = outputs[59]
* NET    11 = outputs[58]
* NET    12 = outputs[57]
* NET    13 = outputs[56]
* NET    14 = outputs[55]
* NET    15 = outputs[54]
* NET    16 = outputs[53]
* NET    17 = outputs[52]
* NET    18 = outputs[51]
* NET    19 = outputs[50]
* NET    20 = outputs[5]
* NET    21 = outputs[49]
* NET    22 = outputs[48]
* NET    23 = outputs[47]
* NET    24 = outputs[46]
* NET    25 = outputs[45]
* NET    26 = outputs[44]
* NET    27 = outputs[43]
* NET    28 = outputs[42]
* NET    29 = outputs[41]
* NET    30 = outputs[40]
* NET    31 = outputs[4]
* NET    32 = outputs[39]
* NET    33 = outputs[38]
* NET    34 = outputs[37]
* NET    35 = outputs[36]
* NET    36 = outputs[35]
* NET    37 = outputs[34]
* NET    38 = outputs[33]
* NET    39 = outputs[32]
* NET    40 = outputs[31]
* NET    41 = outputs[30]
* NET    42 = outputs[3]
* NET    43 = outputs[29]
* NET    44 = outputs[28]
* NET    45 = outputs[27]
* NET    46 = outputs[26]
* NET    47 = outputs[25]
* NET    48 = outputs[24]
* NET    49 = outputs[23]
* NET    50 = outputs[22]
* NET    51 = outputs[21]
* NET    52 = outputs[20]
* NET    53 = outputs[2]
* NET    54 = outputs[19]
* NET    55 = outputs[18]
* NET    56 = outputs[17]
* NET    57 = outputs[16]
* NET    58 = outputs[15]
* NET    59 = outputs[14]
* NET    60 = outputs[13]
* NET    61 = outputs[12]
* NET    62 = outputs[11]
* NET    63 = outputs[10]
* NET    64 = outputs[1]
* NET    65 = outputs[0]
* NET    66 = one_0
* NET    67 = n[9]
* NET    68 = n[8]
* NET    69 = n[7]
* NET    70 = n[6]
* NET    71 = n[5]
* NET    72 = n[4]
* NET    73 = n[31]
* NET    74 = n[30]
* NET    75 = n[3]
* NET    76 = n[29]
* NET    77 = n[28]
* NET    78 = n[27]
* NET    79 = n[26]
* NET    80 = n[25]
* NET    81 = n[24]
* NET    82 = n[23]
* NET    83 = n[22]
* NET    84 = n[21]
* NET    85 = n[20]
* NET    86 = n[2]
* NET    87 = n[19]
* NET    88 = n[18]
* NET    89 = n[17]
* NET    90 = n[16]
* NET    91 = n[15]
* NET    92 = n[14]
* NET    93 = n[13]
* NET    94 = n[12]
* NET    95 = n[11]
* NET    96 = n[10]
* NET    97 = n[1]
* NET    98 = n[0]
* NET    99 = mem_inputs[63]
* NET   100 = mem_inputs[62]
* NET   101 = mem_inputs[61]
* NET   102 = mem_inputs[60]
* NET   103 = mem_inputs[59]
* NET   104 = mem_inputs[58]
* NET   105 = mem_inputs[57]
* NET   106 = mem_inputs[56]
* NET   107 = mem_inputs[55]
* NET   108 = mem_inputs[54]
* NET   109 = mem_inputs[53]
* NET   110 = mem_inputs[52]
* NET   111 = mem_inputs[51]
* NET   112 = mem_inputs[50]
* NET   113 = mem_inputs[49]
* NET   114 = mem_inputs[48]
* NET   115 = mem_inputs[47]
* NET   116 = mem_inputs[46]
* NET   117 = mem_inputs[45]
* NET   118 = mem_inputs[44]
* NET   119 = mem_inputs[43]
* NET   120 = mem_inputs[42]
* NET   121 = mem_inputs[41]
* NET   122 = mem_inputs[40]
* NET   123 = mem_inputs[39]
* NET   124 = mem_inputs[38]
* NET   125 = mem_inputs[37]
* NET   126 = mem_inputs[36]
* NET   127 = mem_inputs[35]
* NET   128 = mem_inputs[34]
* NET   129 = mem_inputs[33]
* NET   130 = mem_inputs[32]
* NET   131 = inputs[9]
* NET   132 = inputs[8]
* NET   133 = inputs[7]
* NET   134 = inputs[63]
* NET   135 = inputs[62]
* NET   136 = inputs[61]
* NET   137 = inputs[60]
* NET   138 = inputs[6]
* NET   139 = inputs[59]
* NET   140 = inputs[58]
* NET   141 = inputs[57]
* NET   142 = inputs[56]
* NET   143 = inputs[55]
* NET   144 = inputs[54]
* NET   145 = inputs[53]
* NET   146 = inputs[52]
* NET   147 = inputs[51]
* NET   148 = inputs[50]
* NET   149 = inputs[5]
* NET   150 = inputs[49]
* NET   151 = inputs[48]
* NET   152 = inputs[47]
* NET   153 = inputs[46]
* NET   154 = inputs[45]
* NET   155 = inputs[44]
* NET   156 = inputs[43]
* NET   157 = inputs[42]
* NET   158 = inputs[41]
* NET   159 = inputs[40]
* NET   160 = inputs[4]
* NET   161 = inputs[39]
* NET   162 = inputs[38]
* NET   163 = inputs[37]
* NET   164 = inputs[36]
* NET   165 = inputs[35]
* NET   166 = inputs[34]
* NET   167 = inputs[33]
* NET   168 = inputs[32]
* NET   169 = inputs[31]
* NET   170 = inputs[30]
* NET   171 = inputs[3]
* NET   172 = inputs[29]
* NET   173 = inputs[28]
* NET   174 = inputs[27]
* NET   175 = inputs[26]
* NET   176 = inputs[25]
* NET   177 = inputs[24]
* NET   178 = inputs[23]
* NET   179 = inputs[22]
* NET   180 = inputs[21]
* NET   181 = inputs[20]
* NET   182 = inputs[2]
* NET   183 = inputs[19]
* NET   184 = inputs[18]
* NET   185 = inputs[17]
* NET   186 = inputs[16]
* NET   187 = inputs[15]
* NET   188 = inputs[14]
* NET   189 = inputs[13]
* NET   190 = inputs[12]
* NET   191 = inputs[11]
* NET   192 = inputs[10]
* NET   193 = inputs[1]
* NET   194 = inputs[0]
* NET   195 = init
* NET   196 = clk
* NET   197 = abc_1658_new_n786
* NET   198 = abc_1658_new_n784
* NET   199 = abc_1658_new_n782
* NET   200 = abc_1658_new_n780
* NET   201 = abc_1658_new_n778
* NET   202 = abc_1658_new_n777
* NET   203 = abc_1658_new_n776
* NET   204 = abc_1658_new_n775
* NET   205 = abc_1658_new_n774
* NET   206 = abc_1658_new_n771
* NET   207 = abc_1658_new_n769
* NET   208 = abc_1658_new_n768
* NET   209 = abc_1658_new_n766
* NET   210 = abc_1658_new_n764
* NET   211 = abc_1658_new_n763
* NET   212 = abc_1658_new_n761
* NET   213 = abc_1658_new_n760
* NET   214 = abc_1658_new_n759
* NET   215 = abc_1658_new_n758
* NET   216 = abc_1658_new_n755
* NET   217 = abc_1658_new_n753
* NET   218 = abc_1658_new_n752
* NET   219 = abc_1658_new_n751
* NET   220 = abc_1658_new_n749
* NET   221 = abc_1658_new_n747
* NET   222 = abc_1658_new_n746
* NET   223 = abc_1658_new_n744
* NET   224 = abc_1658_new_n742
* NET   225 = abc_1658_new_n741
* NET   226 = abc_1658_new_n739
* NET   227 = abc_1658_new_n738
* NET   228 = abc_1658_new_n737
* NET   229 = abc_1658_new_n736
* NET   230 = abc_1658_new_n735
* NET   231 = abc_1658_new_n734
* NET   232 = abc_1658_new_n733
* NET   233 = abc_1658_new_n732
* NET   234 = abc_1658_new_n731
* NET   235 = abc_1658_new_n730
* NET   236 = abc_1658_new_n727
* NET   237 = abc_1658_new_n725
* NET   238 = abc_1658_new_n724
* NET   239 = abc_1658_new_n722
* NET   240 = abc_1658_new_n720
* NET   241 = abc_1658_new_n719
* NET   242 = abc_1658_new_n717
* NET   243 = abc_1658_new_n715
* NET   244 = abc_1658_new_n714
* NET   245 = abc_1658_new_n713
* NET   246 = abc_1658_new_n711
* NET   247 = abc_1658_new_n709
* NET   248 = abc_1658_new_n707
* NET   249 = abc_1658_new_n705
* NET   250 = abc_1658_new_n703
* NET   251 = abc_1658_new_n700
* NET   252 = abc_1658_new_n699
* NET   253 = abc_1658_new_n698
* NET   254 = abc_1658_new_n696
* NET   255 = abc_1658_new_n695
* NET   256 = abc_1658_new_n694
* NET   257 = abc_1658_new_n692
* NET   258 = abc_1658_new_n691
* NET   259 = abc_1658_new_n690
* NET   260 = abc_1658_new_n688
* NET   261 = abc_1658_new_n687
* NET   262 = abc_1658_new_n686
* NET   263 = abc_1658_new_n684
* NET   264 = abc_1658_new_n683
* NET   265 = abc_1658_new_n682
* NET   266 = abc_1658_new_n680
* NET   267 = abc_1658_new_n679
* NET   268 = abc_1658_new_n678
* NET   269 = abc_1658_new_n676
* NET   270 = abc_1658_new_n675
* NET   271 = abc_1658_new_n674
* NET   272 = abc_1658_new_n672
* NET   273 = abc_1658_new_n671
* NET   274 = abc_1658_new_n670
* NET   275 = abc_1658_new_n668
* NET   276 = abc_1658_new_n667
* NET   277 = abc_1658_new_n666
* NET   278 = abc_1658_new_n664
* NET   279 = abc_1658_new_n663
* NET   280 = abc_1658_new_n662
* NET   281 = abc_1658_new_n660
* NET   282 = abc_1658_new_n659
* NET   283 = abc_1658_new_n658
* NET   284 = abc_1658_new_n656
* NET   285 = abc_1658_new_n655
* NET   286 = abc_1658_new_n654
* NET   287 = abc_1658_new_n652
* NET   288 = abc_1658_new_n651
* NET   289 = abc_1658_new_n650
* NET   290 = abc_1658_new_n648
* NET   291 = abc_1658_new_n647
* NET   292 = abc_1658_new_n646
* NET   293 = abc_1658_new_n644
* NET   294 = abc_1658_new_n643
* NET   295 = abc_1658_new_n642
* NET   296 = abc_1658_new_n640
* NET   297 = abc_1658_new_n639
* NET   298 = abc_1658_new_n638
* NET   299 = abc_1658_new_n636
* NET   300 = abc_1658_new_n635
* NET   301 = abc_1658_new_n634
* NET   302 = abc_1658_new_n632
* NET   303 = abc_1658_new_n631
* NET   304 = abc_1658_new_n630
* NET   305 = abc_1658_new_n628
* NET   306 = abc_1658_new_n627
* NET   307 = abc_1658_new_n626
* NET   308 = abc_1658_new_n624
* NET   309 = abc_1658_new_n623
* NET   310 = abc_1658_new_n622
* NET   311 = abc_1658_new_n620
* NET   312 = abc_1658_new_n619
* NET   313 = abc_1658_new_n618
* NET   314 = abc_1658_new_n616
* NET   315 = abc_1658_new_n615
* NET   316 = abc_1658_new_n614
* NET   317 = abc_1658_new_n612
* NET   318 = abc_1658_new_n611
* NET   319 = abc_1658_new_n610
* NET   320 = abc_1658_new_n608
* NET   321 = abc_1658_new_n607
* NET   322 = abc_1658_new_n606
* NET   323 = abc_1658_new_n604
* NET   324 = abc_1658_new_n603
* NET   325 = abc_1658_new_n602
* NET   326 = abc_1658_new_n600
* NET   327 = abc_1658_new_n599
* NET   328 = abc_1658_new_n598
* NET   329 = abc_1658_new_n596
* NET   330 = abc_1658_new_n595
* NET   331 = abc_1658_new_n594
* NET   332 = abc_1658_new_n592
* NET   333 = abc_1658_new_n591
* NET   334 = abc_1658_new_n590
* NET   335 = abc_1658_new_n588
* NET   336 = abc_1658_new_n587
* NET   337 = abc_1658_new_n586
* NET   338 = abc_1658_new_n584
* NET   339 = abc_1658_new_n583
* NET   340 = abc_1658_new_n582
* NET   341 = abc_1658_new_n580
* NET   342 = abc_1658_new_n579
* NET   343 = abc_1658_new_n578
* NET   344 = abc_1658_new_n576
* NET   345 = abc_1658_new_n575
* NET   346 = abc_1658_new_n574
* NET   347 = abc_1658_new_n572
* NET   348 = abc_1658_new_n571
* NET   349 = abc_1658_new_n570
* NET   350 = abc_1658_new_n568
* NET   351 = abc_1658_new_n567
* NET   352 = abc_1658_new_n566
* NET   353 = abc_1658_new_n564
* NET   354 = abc_1658_new_n563
* NET   355 = abc_1658_new_n562
* NET   356 = abc_1658_new_n560
* NET   357 = abc_1658_new_n559
* NET   358 = abc_1658_new_n558
* NET   359 = abc_1658_new_n556
* NET   360 = abc_1658_new_n555
* NET   361 = abc_1658_new_n554
* NET   362 = abc_1658_new_n552
* NET   363 = abc_1658_new_n551
* NET   364 = abc_1658_new_n550
* NET   365 = abc_1658_new_n548
* NET   366 = abc_1658_new_n547
* NET   367 = abc_1658_new_n546
* NET   368 = abc_1658_new_n544
* NET   369 = abc_1658_new_n543
* NET   370 = abc_1658_new_n542
* NET   371 = abc_1658_new_n540
* NET   372 = abc_1658_new_n539
* NET   373 = abc_1658_new_n538
* NET   374 = abc_1658_new_n536
* NET   375 = abc_1658_new_n535
* NET   376 = abc_1658_new_n534
* NET   377 = abc_1658_new_n532
* NET   378 = abc_1658_new_n531
* NET   379 = abc_1658_new_n530
* NET   380 = abc_1658_new_n528
* NET   381 = abc_1658_new_n527
* NET   382 = abc_1658_new_n526
* NET   383 = abc_1658_new_n524
* NET   384 = abc_1658_new_n523
* NET   385 = abc_1658_new_n522
* NET   386 = abc_1658_new_n520
* NET   387 = abc_1658_new_n519
* NET   388 = abc_1658_new_n518
* NET   389 = abc_1658_new_n516
* NET   390 = abc_1658_new_n515
* NET   391 = abc_1658_new_n514
* NET   392 = abc_1658_new_n512
* NET   393 = abc_1658_new_n511
* NET   394 = abc_1658_new_n510
* NET   395 = abc_1658_new_n508
* NET   396 = abc_1658_new_n507
* NET   397 = abc_1658_new_n506
* NET   398 = abc_1658_new_n504
* NET   399 = abc_1658_new_n503
* NET   400 = abc_1658_new_n502
* NET   401 = abc_1658_new_n500
* NET   402 = abc_1658_new_n499
* NET   403 = abc_1658_new_n498
* NET   404 = abc_1658_new_n496
* NET   405 = abc_1658_new_n495
* NET   406 = abc_1658_new_n494
* NET   407 = abc_1658_new_n492
* NET   408 = abc_1658_new_n491
* NET   409 = abc_1658_new_n490
* NET   410 = abc_1658_new_n488
* NET   411 = abc_1658_new_n487
* NET   412 = abc_1658_new_n486
* NET   413 = abc_1658_new_n484
* NET   414 = abc_1658_new_n483
* NET   415 = abc_1658_new_n482
* NET   416 = abc_1658_new_n480
* NET   417 = abc_1658_new_n479
* NET   418 = abc_1658_new_n478
* NET   419 = abc_1658_new_n476
* NET   420 = abc_1658_new_n475
* NET   421 = abc_1658_new_n474
* NET   422 = abc_1658_new_n472
* NET   423 = abc_1658_new_n471
* NET   424 = abc_1658_new_n470
* NET   425 = abc_1658_new_n468
* NET   426 = abc_1658_new_n467
* NET   427 = abc_1658_new_n466
* NET   428 = abc_1658_new_n464
* NET   429 = abc_1658_new_n463
* NET   430 = abc_1658_new_n462
* NET   431 = abc_1658_new_n460
* NET   432 = abc_1658_new_n459
* NET   433 = abc_1658_new_n458
* NET   434 = abc_1658_new_n456
* NET   435 = abc_1658_new_n455
* NET   436 = abc_1658_new_n454
* NET   437 = abc_1658_new_n452
* NET   438 = abc_1658_new_n451
* NET   439 = abc_1658_new_n450
* NET   440 = abc_1658_new_n449
* NET   441 = abc_1658_new_n448
* NET   442 = abc_1658_new_n447
* NET   443 = abc_1658_new_n446
* NET   444 = abc_1658_new_n445
* NET   445 = abc_1658_new_n444
* NET   446 = abc_1658_new_n443
* NET   447 = abc_1658_new_n442
* NET   448 = abc_1658_new_n441
* NET   449 = abc_1658_new_n440
* NET   450 = abc_1658_new_n439
* NET   451 = abc_1658_new_n438
* NET   452 = abc_1658_new_n437
* NET   453 = abc_1658_new_n436
* NET   454 = abc_1658_new_n433
* NET   455 = abc_1658_new_n431
* NET   456 = abc_1658_new_n429
* NET   457 = abc_1658_new_n427
* NET   458 = abc_1658_new_n424
* NET   459 = abc_1658_new_n422
* NET   460 = abc_1658_new_n420
* NET   461 = abc_1658_new_n418
* NET   462 = abc_1658_new_n416
* NET   463 = abc_1658_new_n414
* NET   464 = abc_1658_new_n412
* NET   465 = abc_1658_new_n410
* NET   466 = abc_1658_new_n408
* NET   467 = abc_1658_new_n404
* NET   468 = abc_1658_new_n402
* NET   469 = abc_1658_new_n400
* NET   470 = abc_1658_new_n398
* NET   471 = abc_1658_new_n395
* NET   472 = abc_1658_new_n393
* NET   473 = abc_1658_new_n391
* NET   474 = abc_1658_new_n389
* NET   475 = abc_1658_new_n386
* NET   476 = abc_1658_new_n384
* NET   477 = abc_1658_new_n382
* NET   478 = abc_1658_new_n380
* NET   479 = abc_1658_new_n378
* NET   480 = abc_1658_new_n377
* NET   481 = abc_1658_new_n376
* NET   482 = abc_1658_new_n375
* NET   483 = abc_1658_new_n374
* NET   484 = abc_1658_new_n373
* NET   485 = abc_1658_new_n372
* NET   486 = abc_1658_new_n371
* NET   487 = abc_1658_new_n370
* NET   488 = abc_1658_new_n369
* NET   489 = abc_1658_new_n368
* NET   490 = abc_1658_new_n367
* NET   491 = abc_1658_new_n366
* NET   492 = abc_1658_new_n365
* NET   493 = abc_1658_new_n364
* NET   494 = abc_1658_new_n363
* NET   495 = abc_1658_new_n362
* NET   496 = abc_1658_new_n361
* NET   497 = abc_1658_new_n360
* NET   498 = abc_1658_new_n359
* NET   499 = abc_1658_new_n358
* NET   500 = abc_1658_new_n357
* NET   501 = abc_1658_new_n356
* NET   502 = abc_1658_new_n355
* NET   503 = abc_1658_new_n354
* NET   504 = abc_1658_new_n353
* NET   505 = abc_1658_new_n352
* NET   506 = abc_1658_new_n351
* NET   507 = abc_1658_new_n350
* NET   508 = abc_1658_new_n349
* NET   509 = abc_1658_new_n348
* NET   510 = abc_1658_new_n347
* NET   511 = abc_1658_new_n346
* NET   512 = abc_1658_new_n345
* NET   513 = abc_1658_new_n344
* NET   514 = abc_1658_new_n343
* NET   515 = abc_1658_new_n342
* NET   516 = abc_1658_new_n341
* NET   517 = abc_1658_new_n340
* NET   518 = abc_1658_new_n339
* NET   519 = abc_1658_new_n338
* NET   520 = abc_1658_new_n337
* NET   521 = abc_1658_new_n336
* NET   522 = abc_1658_new_n335
* NET   523 = abc_1658_new_n334
* NET   524 = abc_1658_new_n333
* NET   525 = abc_1658_new_n332
* NET   526 = abc_1658_new_n331
* NET   527 = abc_1658_new_n330
* NET   528 = abc_1658_new_n329
* NET   529 = abc_1658_new_n328
* NET   530 = abc_1658_new_n327
* NET   531 = abc_1658_new_n326
* NET   532 = abc_1658_new_n325
* NET   533 = abc_1658_new_n324
* NET   534 = abc_1658_new_n323
* NET   535 = abc_1658_new_n322
* NET   536 = abc_1658_new_n321
* NET   537 = abc_1658_new_n320
* NET   538 = abc_1658_new_n319
* NET   539 = abc_1658_new_n318
* NET   540 = abc_1658_new_n317
* NET   541 = abc_1658_new_n316
* NET   542 = abc_1658_new_n315
* NET   543 = abc_1658_new_n314
* NET   544 = abc_1658_new_n313
* NET   545 = abc_1658_new_n312
* NET   546 = abc_1658_new_n311
* NET   547 = abc_1658_new_n310
* NET   548 = abc_1658_new_n309
* NET   549 = abc_1658_new_n308
* NET   550 = abc_1658_new_n307
* NET   551 = abc_1658_new_n306
* NET   552 = abc_1658_new_n305
* NET   553 = abc_1658_new_n304
* NET   554 = abc_1658_new_n303
* NET   555 = abc_1658_new_n302
* NET   556 = abc_1658_new_n301
* NET   557 = abc_1658_new_n300
* NET   558 = abc_1658_new_n299
* NET   559 = abc_1658_new_n298
* NET   560 = abc_1658_new_n297
* NET   561 = abc_1658_new_n296
* NET   562 = abc_1658_new_n295
* NET   563 = abc_1658_new_n294
* NET   564 = abc_1658_new_n293
* NET   565 = abc_1658_new_n292
* NET   566 = abc_1658_new_n291
* NET   567 = abc_1658_new_n290
* NET   568 = abc_1658_auto_rtlil_cc_2739_MuxGate_1657
* NET   569 = abc_1658_auto_rtlil_cc_2739_MuxGate_1655
* NET   570 = abc_1658_auto_rtlil_cc_2739_MuxGate_1653
* NET   571 = abc_1658_auto_rtlil_cc_2739_MuxGate_1651
* NET   572 = abc_1658_auto_rtlil_cc_2739_MuxGate_1649
* NET   573 = abc_1658_auto_rtlil_cc_2739_MuxGate_1647
* NET   574 = abc_1658_auto_rtlil_cc_2739_MuxGate_1645
* NET   575 = abc_1658_auto_rtlil_cc_2739_MuxGate_1643
* NET   576 = abc_1658_auto_rtlil_cc_2739_MuxGate_1641
* NET   577 = abc_1658_auto_rtlil_cc_2739_MuxGate_1639
* NET   578 = abc_1658_auto_rtlil_cc_2739_MuxGate_1637
* NET   579 = abc_1658_auto_rtlil_cc_2739_MuxGate_1635
* NET   580 = abc_1658_auto_rtlil_cc_2739_MuxGate_1633
* NET   581 = abc_1658_auto_rtlil_cc_2739_MuxGate_1631
* NET   582 = abc_1658_auto_rtlil_cc_2739_MuxGate_1629
* NET   583 = abc_1658_auto_rtlil_cc_2739_MuxGate_1627
* NET   584 = abc_1658_auto_rtlil_cc_2739_MuxGate_1625
* NET   585 = abc_1658_auto_rtlil_cc_2739_MuxGate_1623
* NET   586 = abc_1658_auto_rtlil_cc_2739_MuxGate_1621
* NET   587 = abc_1658_auto_rtlil_cc_2739_MuxGate_1619
* NET   588 = abc_1658_auto_rtlil_cc_2739_MuxGate_1617
* NET   589 = abc_1658_auto_rtlil_cc_2739_MuxGate_1615
* NET   590 = abc_1658_auto_rtlil_cc_2739_MuxGate_1613
* NET   591 = abc_1658_auto_rtlil_cc_2739_MuxGate_1611
* NET   592 = abc_1658_auto_rtlil_cc_2739_MuxGate_1609
* NET   593 = abc_1658_auto_rtlil_cc_2739_MuxGate_1607
* NET   594 = abc_1658_auto_rtlil_cc_2739_MuxGate_1605
* NET   595 = abc_1658_auto_rtlil_cc_2739_MuxGate_1603
* NET   596 = abc_1658_auto_rtlil_cc_2739_MuxGate_1601
* NET   597 = abc_1658_auto_rtlil_cc_2739_MuxGate_1599
* NET   598 = abc_1658_auto_rtlil_cc_2739_MuxGate_1597
* NET   599 = abc_1658_auto_rtlil_cc_2739_MuxGate_1595
* NET   600 = abc_1658_auto_rtlil_cc_2739_MuxGate_1593
* NET   601 = abc_1658_auto_rtlil_cc_2739_MuxGate_1591
* NET   602 = abc_1658_auto_rtlil_cc_2739_MuxGate_1589
* NET   603 = abc_1658_auto_rtlil_cc_2739_MuxGate_1587
* NET   604 = abc_1658_auto_rtlil_cc_2739_MuxGate_1585
* NET   605 = abc_1658_auto_rtlil_cc_2739_MuxGate_1583
* NET   606 = abc_1658_auto_rtlil_cc_2739_MuxGate_1581
* NET   607 = abc_1658_auto_rtlil_cc_2739_MuxGate_1579
* NET   608 = abc_1658_auto_rtlil_cc_2739_MuxGate_1577
* NET   609 = abc_1658_auto_rtlil_cc_2739_MuxGate_1575
* NET   610 = abc_1658_auto_rtlil_cc_2739_MuxGate_1573
* NET   611 = abc_1658_auto_rtlil_cc_2739_MuxGate_1571
* NET   612 = abc_1658_auto_rtlil_cc_2739_MuxGate_1569
* NET   613 = abc_1658_auto_rtlil_cc_2739_MuxGate_1567
* NET   614 = abc_1658_auto_rtlil_cc_2739_MuxGate_1565
* NET   615 = abc_1658_auto_rtlil_cc_2739_MuxGate_1563
* NET   616 = abc_1658_auto_rtlil_cc_2739_MuxGate_1561
* NET   617 = abc_1658_auto_rtlil_cc_2739_MuxGate_1559
* NET   618 = abc_1658_auto_rtlil_cc_2739_MuxGate_1557
* NET   619 = abc_1658_auto_rtlil_cc_2739_MuxGate_1555
* NET   620 = abc_1658_auto_rtlil_cc_2739_MuxGate_1553
* NET   621 = abc_1658_auto_rtlil_cc_2739_MuxGate_1551
* NET   622 = abc_1658_auto_rtlil_cc_2739_MuxGate_1549
* NET   623 = abc_1658_auto_rtlil_cc_2739_MuxGate_1547
* NET   624 = abc_1658_auto_rtlil_cc_2739_MuxGate_1545
* NET   625 = abc_1658_auto_rtlil_cc_2739_MuxGate_1543
* NET   626 = abc_1658_auto_rtlil_cc_2739_MuxGate_1541
* NET   627 = abc_1658_auto_rtlil_cc_2739_MuxGate_1539
* NET   628 = abc_1658_auto_rtlil_cc_2739_MuxGate_1537
* NET   629 = abc_1658_auto_rtlil_cc_2739_MuxGate_1535
* NET   630 = abc_1658_auto_rtlil_cc_2739_MuxGate_1533
* NET   631 = abc_1658_auto_rtlil_cc_2739_MuxGate_1531
* NET   632 = abc_1658_auto_rtlil_cc_2739_MuxGate_1529
* NET   633 = abc_1658_auto_rtlil_cc_2739_MuxGate_1527
* NET   634 = abc_1658_auto_rtlil_cc_2739_MuxGate_1525
* NET   635 = abc_1658_auto_rtlil_cc_2739_MuxGate_1523
* NET   636 = abc_1658_auto_rtlil_cc_2739_MuxGate_1521
* NET   637 = abc_1658_auto_rtlil_cc_2739_MuxGate_1519
* NET   638 = abc_1658_auto_rtlil_cc_2739_MuxGate_1517
* NET   639 = abc_1658_auto_rtlil_cc_2739_MuxGate_1515
* NET   640 = abc_1658_auto_rtlil_cc_2739_MuxGate_1513
* NET   641 = abc_1658_auto_rtlil_cc_2739_MuxGate_1511
* NET   642 = abc_1658_auto_rtlil_cc_2739_MuxGate_1509
* NET   643 = abc_1658_auto_rtlil_cc_2739_MuxGate_1507
* NET   644 = abc_1658_auto_rtlil_cc_2739_MuxGate_1505
* NET   645 = abc_1658_auto_rtlil_cc_2739_MuxGate_1503
* NET   646 = abc_1658_auto_rtlil_cc_2739_MuxGate_1501
* NET   647 = abc_1658_auto_rtlil_cc_2739_MuxGate_1499
* NET   648 = abc_1658_auto_rtlil_cc_2739_MuxGate_1497
* NET   649 = abc_1658_auto_rtlil_cc_2739_MuxGate_1495
* NET   650 = abc_1658_auto_rtlil_cc_2739_MuxGate_1493
* NET   651 = abc_1658_auto_rtlil_cc_2739_MuxGate_1491
* NET   652 = abc_1658_auto_rtlil_cc_2739_MuxGate_1489
* NET   653 = abc_1658_auto_rtlil_cc_2739_MuxGate_1487
* NET   654 = abc_1658_auto_rtlil_cc_2739_MuxGate_1485
* NET   655 = abc_1658_auto_rtlil_cc_2739_MuxGate_1483
* NET   656 = abc_1658_auto_rtlil_cc_2739_MuxGate_1481
* NET   657 = abc_1658_auto_rtlil_cc_2739_MuxGate_1479
* NET   658 = abc_1658_auto_rtlil_cc_2739_MuxGate_1477
* NET   659 = abc_1658_auto_rtlil_cc_2739_MuxGate_1475
* NET   660 = abc_1658_auto_rtlil_cc_2739_MuxGate_1473
* NET   661 = abc_1658_auto_rtlil_cc_2739_MuxGate_1471
* NET   662 = abc_1658_auto_rtlil_cc_2739_MuxGate_1469
* NET   663 = abc_1658_auto_rtlil_cc_2739_MuxGate_1467

xsubckt_515_dff_x1 1 0 647 196 115 dff_x1
xsubckt_514_dff_x1 1 0 648 196 114 dff_x1
xsubckt_513_dff_x1 1 0 649 196 113 dff_x1
xsubckt_512_dff_x1 1 0 650 196 112 dff_x1
xsubckt_511_dff_x1 1 0 651 196 111 dff_x1
xsubckt_348_nor3_x0 1 0 298 442 526 566 nor3_x0
xsubckt_115_inv_x0 1 0 467 36 inv_x0
xsubckt_113_inv_x0 1 0 468 34 inv_x0
xsubckt_519_dff_x1 1 0 643 196 119 dff_x1
xsubckt_518_dff_x1 1 0 644 196 118 dff_x1
xsubckt_517_dff_x1 1 0 645 196 117 dff_x1
xsubckt_516_dff_x1 1 0 646 196 116 dff_x1
xsubckt_456_and2_x1 1 0 222 92 91 and2_x1
xsubckt_454_and4_x1 1 0 223 225 228 248 92 and4_x1
xsubckt_119_inv_x0 1 0 466 43 inv_x0
xsubckt_92_nexor2_x0 1 0 101 11 477 nexor2_x0
xsubckt_175_or3_x1 1 0 660 428 429 430 or3_x1
xsubckt_320_nor3_x0 1 0 319 442 533 566 nor3_x0
xsubckt_490_nand3_x0 1 0 200 202 204 78 nand3_x0
xsubckt_469_nor2_x0 1 0 214 215 218 nor2_x0
xsubckt_395_or2_x1 1 0 605 263 265 or2_x1
xsubckt_357_nand2_x0 1 0 291 188 566 nand2_x0
xsubckt_234_or21nand_x0 1 0 383 471 440 384 or21nand_x0
xsubckt_243_or3_x1 1 0 643 377 378 379 or3_x1
xsubckt_256_nor3_x0 1 0 367 442 486 566 nor3_x0
xsubckt_316_nor3_x0 1 0 322 442 534 566 nor3_x0
xsubckt_542_dff_x1 1 0 620 196 30 dff_x1
xsubckt_541_dff_x1 1 0 621 196 28 dff_x1
xsubckt_540_dff_x1 1 0 622 196 26 dff_x1
xsubckt_476_and3_x1 1 0 209 211 213 83 and3_x1
xsubckt_461_and4_x1 1 0 219 92 91 90 89 and4_x1
xsubckt_399_or2_x1 1 0 604 260 262 or2_x1
xsubckt_382_or21nand_x0 1 0 272 514 440 273 or21nand_x0
xsubckt_144_inv_x0 1 0 454 42 inv_x0
xsubckt_142_inv_x0 1 0 455 20 inv_x0
xsubckt_140_inv_x0 1 0 456 4 inv_x0
xsubckt_177_nand2_x0 1 0 426 139 566 nand2_x0
xsubckt_247_or3_x1 1 0 642 374 375 376 or3_x1
xsubckt_273_nand2_x0 1 0 354 165 566 nand2_x0
xsubckt_548_dff_x1 1 0 614 196 44 dff_x1
xsubckt_547_dff_x1 1 0 615 196 41 dff_x1
xsubckt_546_dff_x1 1 0 616 196 39 dff_x1
xsubckt_545_dff_x1 1 0 617 196 37 dff_x1
xsubckt_544_dff_x1 1 0 618 196 35 dff_x1
xsubckt_543_dff_x1 1 0 619 196 33 dff_x1
xsubckt_412_mux2_x1 1 0 194 65 195 600 mux2_x1
xsubckt_325_and2_x1 1 0 315 179 566 and2_x1
xsubckt_136_xor2_x0 1 0 125 63 62 xor2_x0
xsubckt_224_nor3_x0 1 0 391 442 494 566 nor3_x0
xsubckt_549_dff_x1 1 0 613 196 46 dff_x1
xsubckt_498_and2_x1 1 0 568 197 73 and2_x1
xsubckt_444_and3_x1 1 0 231 72 71 96 and3_x1
xsubckt_432_nand3_x0 1 0 239 242 69 68 nand3_x0
xsubckt_401_nand2_x0 1 0 258 171 566 nand2_x0
xsubckt_173_and2_x1 1 0 429 137 566 and2_x1
xsubckt_178_or21nand_x0 1 0 425 477 440 426 or21nand_x0
xsubckt_305_nand2_x0 1 0 330 174 566 nand2_x0
xsubckt_479_nand3_x0 1 0 207 208 212 84 nand3_x0
xsubckt_393_nand2_x0 1 0 264 149 566 nand2_x0
xsubckt_89_xor2_x0 1 0 99 6 5 xor2_x0
xsubckt_33_inv_x0 1 0 22 534 inv_x0
xsubckt_32_inv_x0 1 0 19 535 inv_x0
xsubckt_31_inv_x0 1 0 17 536 inv_x0
xsubckt_30_inv_x0 1 0 15 537 inv_x0
xsubckt_209_nand2_x0 1 0 402 147 566 nand2_x0
xsubckt_221_nand2_x0 1 0 393 151 566 nand2_x0
xsubckt_297_nand2_x0 1 0 336 172 566 nand2_x0
xsubckt_575_dff_x1 1 0 588 196 95 dff_x1
xsubckt_574_dff_x1 1 0 589 196 96 dff_x1
xsubckt_573_dff_x1 1 0 590 196 67 dff_x1
xsubckt_572_dff_x1 1 0 591 196 68 dff_x1
xsubckt_571_dff_x1 1 0 592 196 69 dff_x1
xsubckt_570_dff_x1 1 0 593 196 70 dff_x1
xsubckt_431_nexor2_x0 1 0 242 544 592 nexor2_x0
xsubckt_425_and4_x1 1 0 243 248 75 72 71 and4_x1
xsubckt_422_nexor2_x0 1 0 247 545 595 nexor2_x0
xsubckt_39_inv_x0 1 0 35 528 inv_x0
xsubckt_38_inv_x0 1 0 33 529 inv_x0
xsubckt_37_inv_x0 1 0 30 530 inv_x0
xsubckt_36_inv_x0 1 0 28 531 inv_x0
xsubckt_35_inv_x0 1 0 26 532 inv_x0
xsubckt_34_inv_x0 1 0 24 533 inv_x0
xsubckt_170_or21nand_x0 1 0 431 478 440 432 or21nand_x0
xsubckt_278_or21nand_x0 1 0 350 527 440 351 or21nand_x0
xsubckt_579_dff_x1 1 0 584 196 91 dff_x1
xsubckt_578_dff_x1 1 0 585 196 92 dff_x1
xsubckt_577_dff_x1 1 0 586 196 93 dff_x1
xsubckt_576_dff_x1 1 0 587 196 94 dff_x1
xsubckt_378_or21nand_x0 1 0 275 457 440 276 or21nand_x0
xsubckt_326_nor3_x0 1 0 314 442 532 566 nor3_x0
xsubckt_201_and2_x1 1 0 408 145 566 and2_x1
xsubckt_211_or2_x1 1 0 651 401 403 or2_x1
xsubckt_270_or21nand_x0 1 0 356 528 440 357 or21nand_x0
xsubckt_288_and3_x1 1 0 343 442 40 195 and3_x1
xsubckt_473_and2_x1 1 0 211 85 84 and2_x1
xsubckt_471_and4_x1 1 0 212 214 228 248 85 and4_x1
xsubckt_434_and2_x1 1 0 238 68 67 and2_x1
xsubckt_408_and3_x1 1 0 253 442 64 195 and3_x1
xsubckt_329_nand2_x0 1 0 312 180 566 nand2_x0
xsubckt_148_nor4_x0 1 0 451 71 68 67 96 nor4_x0
xsubckt_130_nexor2_x0 1 0 122 57 460 nexor2_x0
xsubckt_60_inv_x0 1 0 102 507 inv_x0
xsubckt_174_nor3_x0 1 0 428 442 507 566 nor3_x0
xsubckt_215_or2_x1 1 0 650 398 400 or2_x1
xsubckt_219_or2_x1 1 0 649 395 397 or2_x1
xsubckt_222_or21nand_x0 1 0 392 534 440 393 or21nand_x0
xsubckt_260_and3_x1 1 0 364 442 33 195 and3_x1
xsubckt_491_nexor2_x0 1 0 201 565 572 nexor2_x0
xsubckt_411_or3_x1 1 0 601 251 252 253 or3_x1
xsubckt_372_nor3_x0 1 0 280 442 520 566 nor3_x0
xsubckt_341_nand2_x0 1 0 303 184 566 nand2_x0
xsubckt_112_nexor2_x0 1 0 112 35 468 nexor2_x0
xsubckt_107_xor2_x0 1 0 109 28 27 xor2_x0
xsubckt_61_inv_x0 1 0 103 506 inv_x0
xsubckt_62_inv_x0 1 0 104 505 inv_x0
xsubckt_63_inv_x0 1 0 105 504 inv_x0
xsubckt_64_inv_x0 1 0 106 503 inv_x0
xsubckt_65_inv_x0 1 0 107 502 inv_x0
xsubckt_66_inv_x0 1 0 108 501 inv_x0
xsubckt_171_or2_x1 1 0 661 431 433 or2_x1
xsubckt_196_and3_x1 1 0 412 442 15 195 and3_x1
xsubckt_482_nexor2_x0 1 0 207 81 575 nexor2_x0
xsubckt_371_or3_x1 1 0 611 281 282 283 or3_x1
xsubckt_322_or21nand_x0 1 0 317 463 440 318 or21nand_x0
xsubckt_155_nor4_x0 1 0 444 82 76 77 74 nor4_x0
xsubckt_103_nexor2_x0 1 0 107 24 472 nexor2_x0
xsubckt_67_inv_x0 1 0 109 500 inv_x0
xsubckt_68_inv_x0 1 0 110 499 inv_x0
xsubckt_69_inv_x0 1 0 111 498 inv_x0
xsubckt_179_or2_x1 1 0 659 425 427 or2_x1
xsubckt_464_nexor2_x0 1 0 220 89 582 nexor2_x0
xsubckt_416_nexor2_x0 1 0 250 97 598 nexor2_x0
xsubckt_400_nor3_x0 1 0 259 442 513 566 nor3_x0
xsubckt_340_nor3_x0 1 0 304 442 528 566 nor3_x0
xsubckt_164_and3_x1 1 0 436 442 6 195 and3_x1
xsubckt_202_nor3_x0 1 0 407 442 500 566 nor3_x0
xsubckt_489_nor2_x0 1 0 573 201 203 nor2_x0
xsubckt_455_nexor2_x0 1 0 224 550 585 nexor2_x0
xsubckt_435_and4_x1 1 0 237 242 69 68 67 and4_x1
xsubckt_365_nand2_x0 1 0 285 190 566 nand2_x0
xsubckt_151_and2_x1 1 0 448 97 86 and2_x1
xsubckt_124_nexor2_x0 1 0 119 50 463 nexor2_x0
xsubckt_93_inv_x0 1 0 477 10 inv_x0
xsubckt_91_inv_x0 1 0 478 7 inv_x0
xsubckt_269_nand2_x0 1 0 357 164 566 nand2_x0
xsubckt_276_nor3_x0 1 0 352 442 481 566 nor3_x0
xsubckt_481_and4_x1 1 0 206 208 212 84 81 and4_x1
xsubckt_336_nor3_x0 1 0 307 442 529 566 nor3_x0
xsubckt_97_inv_x0 1 0 475 14 inv_x0
xsubckt_95_inv_x0 1 0 476 12 inv_x0
xsubckt_266_or21nand_x0 1 0 359 468 440 360 or21nand_x0
xsubckt_311_or2_x1 1 0 626 326 328 or2_x1
xsubckt_315_or2_x1 1 0 625 323 325 or2_x1
xsubckt_428_nexor2_x0 1 0 243 543 593 nexor2_x0
xsubckt_117_xor2_x0 1 0 115 41 40 xor2_x0
xsubckt_184_nor3_x0 1 0 421 442 504 566 nor3_x0
xsubckt_185_nand2_x0 1 0 420 141 566 nand2_x0
xsubckt_218_or21nand_x0 1 0 395 473 440 396 or21nand_x0
xsubckt_271_or2_x1 1 0 636 356 358 or2_x1
xsubckt_319_or2_x1 1 0 624 320 322 or2_x1
xsubckt_467_nexor2_x0 1 0 216 556 580 nexor2_x0
xsubckt_366_or21nand_x0 1 0 284 516 440 285 or21nand_x0
xsubckt_275_or2_x1 1 0 635 353 355 or2_x1
xsubckt_279_or2_x1 1 0 634 350 352 or2_x1
xsubckt_304_nor3_x0 1 0 331 442 537 566 nor3_x0
xsubckt_458_nexor2_x0 1 0 223 551 584 nexor2_x0
xsubckt_451_and2_x1 1 0 225 93 94 and2_x1
xsubckt_343_or2_x1 1 0 618 302 304 or2_x1
xsubckt_4_inv_x0 1 0 73 563 inv_x0
xsubckt_3_inv_x0 1 0 80 564 inv_x0
xsubckt_2_inv_x0 1 0 78 565 inv_x0
xsubckt_1_inv_x0 1 0 195 566 inv_x0
xsubckt_0_inv_x0 1 0 98 567 inv_x0
xsubckt_210_or21nand_x0 1 0 401 474 440 402 or21nand_x0
xsubckt_217_nand2_x0 1 0 396 150 566 nand2_x0
xsubckt_290_nor3_x0 1 0 341 442 541 566 nor3_x0
xsubckt_313_nand2_x0 1 0 324 176 566 nand2_x0
xsubckt_318_or21nand_x0 1 0 320 522 440 321 or21nand_x0
xsubckt_497_nexor2_x0 1 0 198 562 569 nexor2_x0
xsubckt_484_and4_x1 1 0 205 83 82 81 80 and4_x1
xsubckt_445_and4_x1 1 0 230 231 232 238 95 and4_x1
xsubckt_410_nor3_x0 1 0 251 442 511 566 nor3_x0
xsubckt_347_or2_x1 1 0 617 299 301 or2_x1
xsubckt_118_nexor2_x0 1 0 116 44 466 nexor2_x0
xsubckt_9_inv_x0 1 0 84 558 inv_x0
xsubckt_8_inv_x0 1 0 83 559 inv_x0
xsubckt_7_inv_x0 1 0 82 560 inv_x0
xsubckt_6_inv_x0 1 0 76 561 inv_x0
xsubckt_5_inv_x0 1 0 74 562 inv_x0
xsubckt_161_and2_x1 1 0 438 134 566 and2_x1
xsubckt_212_nor3_x0 1 0 400 442 497 566 nor3_x0
xsubckt_486_and21nor_x0 1 0 203 204 213 79 and21nor_x0
xsubckt_90_nexor2_x0 1 0 100 8 478 nexor2_x0
xsubckt_208_nor3_x0 1 0 403 442 498 566 nor3_x0
xsubckt_310_or21nand_x0 1 0 326 523 440 327 or21nand_x0
xsubckt_452_and4_x1 1 0 224 230 248 93 94 and4_x1
xsubckt_368_and3_x1 1 0 283 442 62 195 and3_x1
xsubckt_337_nand2_x0 1 0 306 183 566 nand2_x0
xsubckt_280_and3_x1 1 0 349 442 38 195 and3_x1
xsubckt_487_and4_x1 1 0 202 214 228 248 79 and4_x1
xsubckt_392_nor3_x0 1 0 265 442 515 566 nor3_x0
xsubckt_375_or2_x1 1 0 610 278 280 or2_x1
xsubckt_139_nexor2_x0 1 0 127 9 456 nexor2_x0
xsubckt_253_nand2_x0 1 0 369 159 566 nand2_x0
xsubckt_254_or21nand_x0 1 0 368 530 440 369 or21nand_x0
xsubckt_522_dff_x1 1 0 640 196 122 dff_x1
xsubckt_521_dff_x1 1 0 641 196 121 dff_x1
xsubckt_520_dff_x1 1 0 642 196 120 dff_x1
xsubckt_379_or2_x1 1 0 609 275 277 or2_x1
xsubckt_123_inv_x0 1 0 464 47 inv_x0
xsubckt_121_inv_x0 1 0 465 45 inv_x0
xsubckt_206_or21nand_x0 1 0 404 536 440 405 or21nand_x0
xsubckt_528_dff_x1 1 0 634 196 128 dff_x1
xsubckt_527_dff_x1 1 0 635 196 127 dff_x1
xsubckt_526_dff_x1 1 0 636 196 126 dff_x1
xsubckt_525_dff_x1 1 0 637 196 125 dff_x1
xsubckt_524_dff_x1 1 0 638 196 124 dff_x1
xsubckt_523_dff_x1 1 0 639 196 123 dff_x1
xsubckt_360_nor3_x0 1 0 289 442 523 566 nor3_x0
xsubckt_354_or21nand_x0 1 0 293 459 440 294 or21nand_x0
xsubckt_129_inv_x0 1 0 461 54 inv_x0
xsubckt_127_inv_x0 1 0 462 51 inv_x0
xsubckt_125_inv_x0 1 0 463 49 inv_x0
xsubckt_162_nor3_x0 1 0 437 442 510 566 nor3_x0
xsubckt_183_or3_x1 1 0 658 422 423 424 or3_x1
xsubckt_529_dff_x1 1 0 633 196 129 dff_x1
xsubckt_457_and2_x1 1 0 221 222 224 and2_x1
xsubckt_442_and3_x1 1 0 233 234 235 244 and3_x1
xsubckt_244_and3_x1 1 0 376 442 28 195 and3_x1
xsubckt_296_nor3_x0 1 0 337 442 539 566 nor3_x0
xsubckt_306_or21nand_x0 1 0 329 465 440 330 or21nand_x0
xsubckt_459_nand3_x0 1 0 220 223 91 90 nand3_x0
xsubckt_373_nand2_x0 1 0 279 192 566 nand2_x0
xsubckt_356_nor3_x0 1 0 292 442 524 566 nor3_x0
xsubckt_10_inv_x0 1 0 85 557 inv_x0
xsubckt_11_inv_x0 1 0 87 556 inv_x0
xsubckt_12_inv_x0 1 0 88 555 inv_x0
xsubckt_13_inv_x0 1 0 90 554 inv_x0
xsubckt_14_inv_x0 1 0 94 553 inv_x0
xsubckt_190_or21nand_x0 1 0 416 538 440 417 or21nand_x0
xsubckt_277_nand2_x0 1 0 351 166 566 nand2_x0
xsubckt_298_or21nand_x0 1 0 335 466 440 336 or21nand_x0
xsubckt_555_dff_x1 1 0 607 196 59 dff_x1
xsubckt_554_dff_x1 1 0 608 196 57 dff_x1
xsubckt_553_dff_x1 1 0 609 196 55 dff_x1
xsubckt_552_dff_x1 1 0 610 196 52 dff_x1
xsubckt_551_dff_x1 1 0 611 196 50 dff_x1
xsubckt_550_dff_x1 1 0 612 196 48 dff_x1
xsubckt_420_nexor2_x0 1 0 248 542 596 nexor2_x0
xsubckt_406_or21nand_x0 1 0 254 511 440 255 or21nand_x0
xsubckt_15_inv_x0 1 0 93 552 inv_x0
xsubckt_16_inv_x0 1 0 91 551 inv_x0
xsubckt_17_inv_x0 1 0 92 550 inv_x0
xsubckt_18_inv_x0 1 0 95 549 inv_x0
xsubckt_19_inv_x0 1 0 96 548 inv_x0
xsubckt_193_nand2_x0 1 0 414 143 566 nand2_x0
xsubckt_559_dff_x1 1 0 603 196 9 dff_x1
xsubckt_558_dff_x1 1 0 604 196 3 dff_x1
xsubckt_557_dff_x1 1 0 605 196 63 dff_x1
xsubckt_556_dff_x1 1 0 606 196 61 dff_x1
xsubckt_405_nand2_x0 1 0 255 182 566 nand2_x0
xsubckt_398_or21nand_x0 1 0 260 512 440 261 or21nand_x0
xsubckt_96_nexor2_x0 1 0 103 15 475 nexor2_x0
xsubckt_264_nor3_x0 1 0 361 442 484 566 nor3_x0
xsubckt_309_nand2_x0 1 0 327 175 566 nand2_x0
xsubckt_450_nexor2_x0 1 0 227 553 587 nexor2_x0
xsubckt_397_nand2_x0 1 0 261 160 566 nand2_x0
xsubckt_333_and2_x1 1 0 309 181 566 and2_x1
xsubckt_327_or3_x1 1 0 622 314 315 316 or3_x1
xsubckt_321_nand2_x0 1 0 318 178 566 nand2_x0
xsubckt_150_nand4_x0 1 0 449 450 451 452 453 nand4_x0
xsubckt_146_nor4_x0 1 0 453 95 92 91 93 nor4_x0
xsubckt_40_inv_x0 1 0 37 527 inv_x0
xsubckt_283_or3_x1 1 0 633 347 348 349 or3_x1
xsubckt_582_dff_x1 1 0 581 196 88 dff_x1
xsubckt_581_dff_x1 1 0 582 196 89 dff_x1
xsubckt_580_dff_x1 1 0 583 196 90 dff_x1
xsubckt_413_nand3_x0 1 0 250 442 195 98 nand3_x0
xsubckt_370_nor3_x0 1 0 281 442 521 566 nor3_x0
xsubckt_110_nexor2_x0 1 0 111 33 469 nexor2_x0
xsubckt_41_inv_x0 1 0 39 526 inv_x0
xsubckt_42_inv_x0 1 0 41 525 inv_x0
xsubckt_43_inv_x0 1 0 44 524 inv_x0
xsubckt_44_inv_x0 1 0 46 523 inv_x0
xsubckt_45_inv_x0 1 0 48 522 inv_x0
xsubckt_46_inv_x0 1 0 50 521 inv_x0
xsubckt_181_and2_x1 1 0 423 140 566 and2_x1
xsubckt_225_nand2_x0 1 0 390 152 566 nand2_x0
xsubckt_232_nor3_x0 1 0 385 442 492 566 nor3_x0
xsubckt_588_dff_x1 1 0 575 196 81 dff_x1
xsubckt_587_dff_x1 1 0 576 196 82 dff_x1
xsubckt_586_dff_x1 1 0 577 196 83 dff_x1
xsubckt_585_dff_x1 1 0 578 196 84 dff_x1
xsubckt_584_dff_x1 1 0 579 196 85 dff_x1
xsubckt_583_dff_x1 1 0 580 196 87 dff_x1
xsubckt_480_nexor2_x0 1 0 209 560 576 nexor2_x0
xsubckt_342_or21nand_x0 1 0 302 519 440 303 or21nand_x0
xsubckt_153_nor4_x0 1 0 446 81 80 79 78 nor4_x0
xsubckt_101_nexor2_x0 1 0 106 22 473 nexor2_x0
xsubckt_47_inv_x0 1 0 52 520 inv_x0
xsubckt_48_inv_x0 1 0 55 519 inv_x0
xsubckt_49_inv_x0 1 0 57 518 inv_x0
xsubckt_168_nor3_x0 1 0 433 442 508 566 nor3_x0
xsubckt_186_or21nand_x0 1 0 419 476 440 420 or21nand_x0
xsubckt_228_nor3_x0 1 0 388 442 493 566 nor3_x0
xsubckt_241_and2_x1 1 0 378 156 566 and2_x1
xsubckt_589_dff_x1 1 0 574 196 80 dff_x1
xsubckt_474_and2_x1 1 0 210 212 84 and2_x1
xsubckt_415_nand4_x0 1 0 249 442 97 195 98 nand4_x0
xsubckt_414_nexor2_x0 1 0 441 567 599 nexor2_x0
xsubckt_388_and3_x1 1 0 268 442 9 195 and3_x1
xsubckt_99_nexor2_x0 1 0 105 19 474 nexor2_x0
xsubckt_223_or2_x1 1 0 648 392 394 or2_x1
xsubckt_453_nexor2_x0 1 0 226 552 586 nexor2_x0
xsubckt_345_nand2_x0 1 0 300 185 566 nand2_x0
xsubckt_149_nor4_x0 1 0 450 75 70 69 72 nor4_x0
xsubckt_122_nexor2_x0 1 0 118 48 464 nexor2_x0
xsubckt_70_inv_x0 1 0 112 497 inv_x0
xsubckt_71_inv_x0 1 0 113 496 inv_x0
xsubckt_72_inv_x0 1 0 114 495 inv_x0
xsubckt_73_inv_x0 1 0 115 494 inv_x0
xsubckt_227_or2_x1 1 0 647 389 391 or2_x1
xsubckt_249_nand2_x0 1 0 372 158 566 nand2_x0
xsubckt_286_or21nand_x0 1 0 344 526 440 345 or21nand_x0
xsubckt_468_nand4_x0 1 0 215 93 94 88 87 nand4_x0
xsubckt_429_and4_x1 1 0 241 244 248 70 69 and4_x1
xsubckt_334_nor3_x0 1 0 308 442 530 566 nor3_x0
xsubckt_159_nand2_x0 1 0 440 442 195 nand2_x0
xsubckt_74_inv_x0 1 0 116 493 inv_x0
xsubckt_75_inv_x0 1 0 117 492 inv_x0
xsubckt_76_inv_x0 1 0 118 491 inv_x0
xsubckt_77_inv_x0 1 0 119 490 inv_x0
xsubckt_78_inv_x0 1 0 120 489 inv_x0
xsubckt_79_inv_x0 1 0 121 488 inv_x0
xsubckt_187_or2_x1 1 0 657 419 421 or2_x1
xsubckt_238_or21nand_x0 1 0 380 532 440 381 or21nand_x0
xsubckt_483_nexor2_x0 1 0 206 564 574 nexor2_x0
xsubckt_426_nexor2_x0 1 0 246 546 594 nexor2_x0
xsubckt_386_or21nand_x0 1 0 269 456 440 270 or21nand_x0
xsubckt_380_nor3_x0 1 0 274 442 518 566 nor3_x0
xsubckt_182_nor3_x0 1 0 422 442 505 566 nor3_x0
xsubckt_242_nor3_x0 1 0 377 442 490 566 nor3_x0
xsubckt_251_or2_x1 1 0 641 371 373 or2_x1
xsubckt_496_nand3_x0 1 0 197 199 76 74 nand3_x0
xsubckt_338_or21nand_x0 1 0 305 461 440 306 or21nand_x0
xsubckt_324_and3_x1 1 0 316 442 50 195 and3_x1
xsubckt_143_nexor2_x0 1 0 129 53 454 nexor2_x0
xsubckt_134_nexor2_x0 1 0 124 61 458 nexor2_x0
xsubckt_230_or21nand_x0 1 0 386 533 440 387 or21nand_x0
xsubckt_255_or2_x1 1 0 640 368 370 or2_x1
xsubckt_259_or2_x1 1 0 639 365 367 or2_x1
xsubckt_381_nand2_x0 1 0 273 132 566 nand2_x0
xsubckt_376_nor3_x0 1 0 277 442 519 566 nor3_x0
xsubckt_323_or2_x1 1 0 623 317 319 or2_x1
xsubckt_285_nand2_x0 1 0 345 168 566 nand2_x0
xsubckt_495_nexor2_x0 1 0 199 561 570 nexor2_x0
xsubckt_438_nexor2_x0 1 0 237 548 589 nexor2_x0
xsubckt_330_or21nand_x0 1 0 311 462 440 312 or21nand_x0
xsubckt_172_and3_x1 1 0 430 442 8 195 and3_x1
xsubckt_189_nand2_x0 1 0 417 142 566 nand2_x0
xsubckt_477_nexor2_x0 1 0 210 559 577 nexor2_x0
xsubckt_344_nor3_x0 1 0 301 442 527 566 nor3_x0
xsubckt_284_nor3_x0 1 0 346 442 479 566 nor3_x0
xsubckt_404_nor3_x0 1 0 256 442 512 566 nor3_x0
xsubckt_137_nexor2_x0 1 0 126 3 457 nexor2_x0
xsubckt_274_or21nand_x0 1 0 353 467 440 354 or21nand_x0
xsubckt_287_or2_x1 1 0 632 344 346 or2_x1
xsubckt_317_nand2_x0 1 0 321 177 566 nand2_x0
xsubckt_390_nor3_x0 1 0 266 442 516 566 nor3_x0
xsubckt_355_or2_x1 1 0 615 293 295 or2_x1
xsubckt_351_or2_x1 1 0 616 296 298 or2_x1
xsubckt_128_nexor2_x0 1 0 121 55 461 nexor2_x0
xsubckt_192_nor3_x0 1 0 415 442 502 566 nor3_x0
xsubckt_200_and3_x1 1 0 409 442 16 195 and3_x1
xsubckt_203_or3_x1 1 0 653 407 408 409 or3_x1
xsubckt_233_nand2_x0 1 0 384 154 566 nand2_x0
xsubckt_252_nor3_x0 1 0 370 442 487 566 nor3_x0
xsubckt_289_and2_x1 1 0 342 169 566 and2_x1
xsubckt_312_nor3_x0 1 0 325 442 535 566 nor3_x0
xsubckt_503_dff_x1 1 0 659 196 103 dff_x1
xsubckt_502_dff_x1 1 0 660 196 102 dff_x1
xsubckt_501_dff_x1 1 0 661 196 101 dff_x1
xsubckt_500_dff_x1 1 0 662 196 100 dff_x1
xsubckt_448_and2_x1 1 0 227 228 248 and2_x1
xsubckt_409_and2_x1 1 0 252 193 566 and2_x1
xsubckt_374_or21nand_x0 1 0 278 515 440 279 or21nand_x0
xsubckt_359_or2_x1 1 0 614 290 292 or2_x1
xsubckt_104_inv_x0 1 0 472 23 inv_x0
xsubckt_102_inv_x0 1 0 473 21 inv_x0
xsubckt_100_inv_x0 1 0 474 18 inv_x0
xsubckt_188_nor3_x0 1 0 418 442 503 566 nor3_x0
xsubckt_226_or21nand_x0 1 0 389 472 440 390 or21nand_x0
xsubckt_261_and2_x1 1 0 363 162 566 and2_x1
xcmpt_one_0 1 0 66 one_x1
xsubckt_508_dff_x1 1 0 654 196 108 dff_x1
xsubckt_507_dff_x1 1 0 655 196 107 dff_x1
xsubckt_506_dff_x1 1 0 656 196 106 dff_x1
xsubckt_505_dff_x1 1 0 657 196 105 dff_x1
xsubckt_504_dff_x1 1 0 658 196 104 dff_x1
xsubckt_494_and2_x1 1 0 198 199 76 and2_x1
xsubckt_492_and4_x1 1 0 199 202 204 77 78 and4_x1
xsubckt_158_and2_x1 1 0 441 442 195 and2_x1
xsubckt_109_inv_x0 1 0 470 29 inv_x0
xsubckt_106_inv_x0 1 0 471 25 inv_x0
xsubckt_163_or3_x1 1 0 663 437 438 439 or3_x1
xsubckt_197_and2_x1 1 0 411 144 566 and2_x1
xsubckt_220_nor3_x0 1 0 394 442 495 566 nor3_x0
xsubckt_248_nor3_x0 1 0 373 442 488 566 nor3_x0
xsubckt_308_nor3_x0 1 0 328 442 536 566 nor3_x0
xsubckt_509_dff_x1 1 0 653 196 109 dff_x1
xsubckt_353_nand2_x0 1 0 294 187 566 nand2_x0
xsubckt_167_or3_x1 1 0 662 434 435 436 or3_x1
xsubckt_387_or2_x1 1 0 607 269 271 or2_x1
xsubckt_383_or2_x1 1 0 608 272 274 or2_x1
xsubckt_131_inv_x0 1 0 460 56 inv_x0
xsubckt_165_and2_x1 1 0 435 135 566 and2_x1
xsubckt_216_nor3_x0 1 0 397 442 496 566 nor3_x0
xsubckt_257_nand2_x0 1 0 366 161 566 nand2_x0
xsubckt_535_dff_x1 1 0 627 196 15 dff_x1
xsubckt_534_dff_x1 1 0 628 196 13 dff_x1
xsubckt_533_dff_x1 1 0 629 196 11 dff_x1
xsubckt_532_dff_x1 1 0 630 196 8 dff_x1
xsubckt_531_dff_x1 1 0 631 196 6 dff_x1
xsubckt_530_dff_x1 1 0 632 196 130 dff_x1
xsubckt_423_and2_x1 1 0 245 72 71 and2_x1
xsubckt_135_inv_x0 1 0 458 60 inv_x0
xsubckt_133_inv_x0 1 0 459 58 inv_x0
xsubckt_539_dff_x1 1 0 623 196 24 dff_x1
xsubckt_538_dff_x1 1 0 624 196 22 dff_x1
xsubckt_537_dff_x1 1 0 625 196 19 dff_x1
xsubckt_536_dff_x1 1 0 626 196 17 dff_x1
xsubckt_417_and4_x1 1 0 248 442 448 195 98 and4_x1
xsubckt_138_inv_x0 1 0 457 2 inv_x0
xsubckt_94_nexor2_x0 1 0 102 13 476 nexor2_x0
xsubckt_199_or3_x1 1 0 654 410 411 412 or3_x1
xsubckt_262_nor3_x0 1 0 362 442 485 566 nor3_x0
xsubckt_443_and3_x1 1 0 232 75 70 69 and3_x1
xsubckt_430_and2_x1 1 0 240 70 69 and2_x1
xsubckt_419_and2_x1 1 0 247 248 75 and2_x1
xsubckt_396_nor3_x0 1 0 262 442 514 566 nor3_x0
xsubckt_377_nand2_x0 1 0 276 131 566 nand2_x0
xsubckt_21_inv_x0 1 0 71 546 inv_x0
xsubckt_20_inv_x0 1 0 68 547 inv_x0
xsubckt_198_nor3_x0 1 0 410 442 501 566 nor3_x0
xsubckt_205_nand2_x0 1 0 405 146 566 nand2_x0
xsubckt_263_or3_x1 1 0 638 362 363 364 or3_x1
xsubckt_301_nand2_x0 1 0 333 173 566 nand2_x0
xsubckt_562_dff_x1 1 0 600 196 65 dff_x1
xsubckt_561_dff_x1 1 0 601 196 53 dff_x1
xsubckt_560_dff_x1 1 0 602 196 31 dff_x1
xsubckt_499_dff_x1 1 0 663 196 99 dff_x1
xsubckt_465_and2_x1 1 0 216 217 88 and2_x1
xsubckt_463_and4_x1 1 0 217 219 225 233 248 and4_x1
xsubckt_26_inv_x0 1 0 6 541 inv_x0
xsubckt_25_inv_x0 1 0 75 542 inv_x0
xsubckt_24_inv_x0 1 0 70 543 inv_x0
xsubckt_23_inv_x0 1 0 69 544 inv_x0
xsubckt_22_inv_x0 1 0 72 545 inv_x0
xsubckt_214_or21nand_x0 1 0 398 535 440 399 or21nand_x0
xsubckt_293_nand2_x0 1 0 339 170 566 nand2_x0
xsubckt_568_dff_x1 1 0 595 196 72 dff_x1
xsubckt_567_dff_x1 1 0 596 196 75 dff_x1
xsubckt_566_dff_x1 1 0 597 196 86 dff_x1
xsubckt_565_dff_x1 1 0 598 196 97 dff_x1
xsubckt_564_dff_x1 1 0 599 196 98 dff_x1
xsubckt_563_dff_x1 1 0 66 196 195 dff_x1
xsubckt_364_nor3_x0 1 0 286 442 522 566 nor3_x0
xsubckt_362_or21nand_x0 1 0 287 458 440 288 or21nand_x0
xsubckt_29_inv_x0 1 0 13 538 inv_x0
xsubckt_28_inv_x0 1 0 11 539 inv_x0
xsubckt_27_inv_x0 1 0 8 540 inv_x0
xsubckt_166_nor3_x0 1 0 434 442 509 566 nor3_x0
xsubckt_569_dff_x1 1 0 594 196 71 dff_x1
xsubckt_460_nexor2_x0 1 0 221 554 583 nexor2_x0
xsubckt_446_and3_x1 1 0 229 68 67 95 and3_x1
xsubckt_335_or3_x1 1 0 620 308 309 310 or3_x1
xsubckt_160_and3_x1 1 0 439 442 5 195 and3_x1
xsubckt_314_or21nand_x0 1 0 323 464 440 324 or21nand_x0
xsubckt_147_nor4_x0 1 0 452 94 90 89 88 nor4_x0
xsubckt_145_xor2_x0 1 0 130 65 64 xor2_x0
xsubckt_120_nexor2_x0 1 0 117 46 465 nexor2_x0
xsubckt_50_inv_x0 1 0 59 517 inv_x0
xsubckt_51_inv_x0 1 0 61 516 inv_x0
xsubckt_52_inv_x0 1 0 63 515 inv_x0
xsubckt_53_inv_x0 1 0 3 514 inv_x0
xsubckt_207_or2_x1 1 0 652 404 406 or2_x1
xsubckt_229_nand2_x0 1 0 387 153 566 nand2_x0
xsubckt_272_nor3_x0 1 0 355 442 482 566 nor3_x0
xsubckt_291_or3_x1 1 0 631 341 342 343 or3_x1
xsubckt_595_dff_x1 1 0 568 196 73 dff_x1
xsubckt_594_dff_x1 1 0 569 196 74 dff_x1
xsubckt_593_dff_x1 1 0 570 196 76 dff_x1
xsubckt_592_dff_x1 1 0 571 196 77 dff_x1
xsubckt_591_dff_x1 1 0 572 196 78 dff_x1
xsubckt_590_dff_x1 1 0 573 196 79 dff_x1
xsubckt_433_nexor2_x0 1 0 241 547 591 nexor2_x0
xsubckt_427_and4_x1 1 0 242 245 248 75 70 and4_x1
xsubckt_369_and2_x1 1 0 282 191 566 and2_x1
xsubckt_54_inv_x0 1 0 9 513 inv_x0
xsubckt_55_inv_x0 1 0 31 512 inv_x0
xsubckt_56_inv_x0 1 0 53 511 inv_x0
xsubckt_57_inv_x0 1 0 99 510 inv_x0
xsubckt_58_inv_x0 1 0 100 509 inv_x0
xsubckt_59_inv_x0 1 0 101 508 inv_x0
xsubckt_258_or21nand_x0 1 0 365 469 440 366 or21nand_x0
xsubckt_281_and2_x1 1 0 348 167 566 and2_x1
xsubckt_472_nexor2_x0 1 0 213 557 579 nexor2_x0
xsubckt_440_and2_x1 1 0 235 96 95 and2_x1
xsubckt_328_nor3_x0 1 0 313 442 531 566 nor3_x0
xsubckt_154_nor4_x0 1 0 445 87 85 84 83 nor4_x0
xsubckt_141_nexor2_x0 1 0 128 31 455 nexor2_x0
xsubckt_98_xor2_x0 1 0 104 17 16 xor2_x0
xsubckt_231_or2_x1 1 0 646 386 388 or2_x1
xsubckt_268_nor3_x0 1 0 358 442 483 566 nor3_x0
xsubckt_449_and3_x1 1 0 226 230 248 94 and3_x1
xsubckt_358_or21nand_x0 1 0 290 517 440 291 or21nand_x0
xsubckt_349_nand2_x0 1 0 297 186 566 nand2_x0
xsubckt_132_nexor2_x0 1 0 123 59 459 nexor2_x0
xsubckt_80_inv_x0 1 0 122 487 inv_x0
xsubckt_176_nor3_x0 1 0 427 442 506 566 nor3_x0
xsubckt_235_or2_x1 1 0 645 383 385 or2_x1
xsubckt_239_or2_x1 1 0 644 380 382 or2_x1
xsubckt_250_or21nand_x0 1 0 371 470 440 372 or21nand_x0
xsubckt_300_nor3_x0 1 0 334 442 538 566 nor3_x0
xsubckt_421_and3_x1 1 0 246 248 75 72 and3_x1
xsubckt_361_nand2_x0 1 0 288 189 566 nand2_x0
xsubckt_114_nexor2_x0 1 0 113 37 467 nexor2_x0
xsubckt_86_inv_x0 1 0 128 481 inv_x0
xsubckt_85_inv_x0 1 0 127 482 inv_x0
xsubckt_84_inv_x0 1 0 126 483 inv_x0
xsubckt_83_inv_x0 1 0 125 484 inv_x0
xsubckt_82_inv_x0 1 0 124 485 inv_x0
xsubckt_81_inv_x0 1 0 123 486 inv_x0
xsubckt_169_nand2_x0 1 0 432 136 566 nand2_x0
xsubckt_191_or2_x1 1 0 656 416 418 or2_x1
xsubckt_195_or2_x1 1 0 655 413 415 or2_x1
xsubckt_236_nor3_x0 1 0 382 442 491 566 nor3_x0
xsubckt_265_nand2_x0 1 0 360 163 566 nand2_x0
xsubckt_303_or2_x1 1 0 628 332 334 or2_x1
xsubckt_493_nexor2_x0 1 0 200 77 571 nexor2_x0
xsubckt_441_and4_x1 1 0 234 70 69 68 67 and4_x1
xsubckt_436_nexor2_x0 1 0 239 67 590 nexor2_x0
xsubckt_391_or3_x1 1 0 606 266 267 268 or3_x1
xsubckt_350_or21nand_x0 1 0 296 518 440 297 or21nand_x0
xsubckt_105_nexor2_x0 1 0 108 26 471 nexor2_x0
xsubckt_88_inv_x0 1 0 130 479 inv_x0
xsubckt_87_inv_x0 1 0 129 480 inv_x0
xsubckt_194_or21nand_x0 1 0 413 475 440 414 or21nand_x0
xsubckt_245_and2_x1 1 0 375 157 566 and2_x1
xsubckt_307_or2_x1 1 0 627 329 331 or2_x1
xsubckt_478_and2_x1 1 0 208 83 82 and2_x1
xsubckt_475_nexor2_x0 1 0 212 558 578 nexor2_x0
xsubckt_418_nexor2_x0 1 0 249 86 597 nexor2_x0
xsubckt_116_xor2_x0 1 0 114 39 38 xor2_x0
xsubckt_204_nor3_x0 1 0 406 442 499 566 nor3_x0
xsubckt_282_nor3_x0 1 0 347 442 480 566 nor3_x0
xsubckt_302_or21nand_x0 1 0 332 524 440 333 or21nand_x0
xsubckt_466_nexor2_x0 1 0 217 555 581 nexor2_x0
xsubckt_437_and4_x1 1 0 236 241 68 67 96 and4_x1
xsubckt_424_and3_x1 1 0 244 75 72 71 and3_x1
xsubckt_385_nand2_x0 1 0 270 133 566 nand2_x0
xsubckt_157_or21nand_x0 1 0 442 443 449 563 or21nand_x0
xsubckt_152_nand2_x0 1 0 447 97 86 nand2_x0
xsubckt_267_or2_x1 1 0 637 359 361 or2_x1
xsubckt_294_or21nand_x0 1 0 338 525 440 339 or21nand_x0
xsubckt_485_and2_x1 1 0 204 205 211 and2_x1
xsubckt_402_or21nand_x0 1 0 257 454 440 258 or21nand_x0
xsubckt_331_or2_x1 1 0 621 311 313 or2_x1
xsubckt_126_nexor2_x0 1 0 120 52 462 nexor2_x0
xsubckt_213_nand2_x0 1 0 399 148 566 nand2_x0
xsubckt_470_and3_x1 1 0 213 214 228 248 and3_x1
xsubckt_439_nexor2_x0 1 0 236 549 588 nexor2_x0
xsubckt_394_or21nand_x0 1 0 263 455 440 264 or21nand_x0
xsubckt_384_nor3_x0 1 0 271 442 517 566 nor3_x0
xsubckt_339_or2_x1 1 0 619 305 307 or2_x1
xsubckt_332_and3_x1 1 0 310 442 52 195 and3_x1
xsubckt_108_nexor2_x0 1 0 110 30 470 nexor2_x0
xsubckt_246_nor3_x0 1 0 374 442 489 566 nor3_x0
xsubckt_403_or2_x1 1 0 603 257 259 or2_x1
xsubckt_346_or21nand_x0 1 0 299 460 440 300 or21nand_x0
xsubckt_156_nand4_x0 1 0 443 444 445 446 447 nand4_x0
xsubckt_180_and3_x1 1 0 424 442 11 195 and3_x1
xsubckt_295_or2_x1 1 0 630 338 340 or2_x1
xsubckt_407_or2_x1 1 0 602 254 256 or2_x1
xsubckt_363_or2_x1 1 0 613 287 289 or2_x1
xsubckt_237_nand2_x0 1 0 381 155 566 nand2_x0
xsubckt_240_and3_x1 1 0 379 442 27 195 and3_x1
xsubckt_292_nor3_x0 1 0 340 442 540 566 nor3_x0
xsubckt_299_or2_x1 1 0 629 335 337 or2_x1
xsubckt_510_dff_x1 1 0 652 196 110 dff_x1
xsubckt_488_and2_x1 1 0 201 202 204 and2_x1
xsubckt_462_nand4_x0 1 0 218 92 91 90 89 nand4_x0
xsubckt_447_and4_x1 1 0 228 229 240 244 96 and4_x1
xsubckt_389_and2_x1 1 0 267 138 566 and2_x1
xsubckt_367_or2_x1 1 0 612 284 286 or2_x1
xsubckt_352_nor3_x0 1 0 295 442 525 566 nor3_x0
xsubckt_111_inv_x0 1 0 469 32 inv_x0
.ends expmob2
