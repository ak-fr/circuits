* Coriolis Structural SPICE Driver
* Generated on Apr 19, 2025, 02:58
* Cell/Subckt "expmob2".
*
* INTERF vss
* INTERF vdd
* INTERF outputs[9]
* INTERF outputs[8]
* INTERF outputs[7]
* INTERF outputs[63]
* INTERF outputs[62]
* INTERF outputs[61]
* INTERF outputs[60]
* INTERF outputs[6]
* INTERF outputs[59]
* INTERF outputs[58]
* INTERF outputs[57]
* INTERF outputs[56]
* INTERF outputs[55]
* INTERF outputs[54]
* INTERF outputs[53]
* INTERF outputs[52]
* INTERF outputs[51]
* INTERF outputs[50]
* INTERF outputs[5]
* INTERF outputs[49]
* INTERF outputs[48]
* INTERF outputs[47]
* INTERF outputs[46]
* INTERF outputs[45]
* INTERF outputs[44]
* INTERF outputs[43]
* INTERF outputs[42]
* INTERF outputs[41]
* INTERF outputs[40]
* INTERF outputs[4]
* INTERF outputs[39]
* INTERF outputs[38]
* INTERF outputs[37]
* INTERF outputs[36]
* INTERF outputs[35]
* INTERF outputs[34]
* INTERF outputs[33]
* INTERF outputs[32]
* INTERF outputs[31]
* INTERF outputs[30]
* INTERF outputs[3]
* INTERF outputs[29]
* INTERF outputs[28]
* INTERF outputs[27]
* INTERF outputs[26]
* INTERF outputs[25]
* INTERF outputs[24]
* INTERF outputs[23]
* INTERF outputs[22]
* INTERF outputs[21]
* INTERF outputs[20]
* INTERF outputs[2]
* INTERF outputs[19]
* INTERF outputs[18]
* INTERF outputs[17]
* INTERF outputs[16]
* INTERF outputs[15]
* INTERF outputs[14]
* INTERF outputs[13]
* INTERF outputs[12]
* INTERF outputs[11]
* INTERF outputs[10]
* INTERF outputs[1]
* INTERF outputs[0]
* INTERF inputs[9]
* INTERF inputs[8]
* INTERF inputs[7]
* INTERF inputs[63]
* INTERF inputs[62]
* INTERF inputs[61]
* INTERF inputs[60]
* INTERF inputs[6]
* INTERF inputs[59]
* INTERF inputs[58]
* INTERF inputs[57]
* INTERF inputs[56]
* INTERF inputs[55]
* INTERF inputs[54]
* INTERF inputs[53]
* INTERF inputs[52]
* INTERF inputs[51]
* INTERF inputs[50]
* INTERF inputs[5]
* INTERF inputs[49]
* INTERF inputs[48]
* INTERF inputs[47]
* INTERF inputs[46]
* INTERF inputs[45]
* INTERF inputs[44]
* INTERF inputs[43]
* INTERF inputs[42]
* INTERF inputs[41]
* INTERF inputs[40]
* INTERF inputs[4]
* INTERF inputs[39]
* INTERF inputs[38]
* INTERF inputs[37]
* INTERF inputs[36]
* INTERF inputs[35]
* INTERF inputs[34]
* INTERF inputs[33]
* INTERF inputs[32]
* INTERF inputs[31]
* INTERF inputs[30]
* INTERF inputs[3]
* INTERF inputs[29]
* INTERF inputs[28]
* INTERF inputs[27]
* INTERF inputs[26]
* INTERF inputs[25]
* INTERF inputs[24]
* INTERF inputs[23]
* INTERF inputs[22]
* INTERF inputs[21]
* INTERF inputs[20]
* INTERF inputs[2]
* INTERF inputs[19]
* INTERF inputs[18]
* INTERF inputs[17]
* INTERF inputs[16]
* INTERF inputs[15]
* INTERF inputs[14]
* INTERF inputs[13]
* INTERF inputs[12]
* INTERF inputs[11]
* INTERF inputs[10]
* INTERF inputs[1]
* INTERF inputs[0]
* INTERF clk

* Terminal models (aka standard cells) used througout all the hierarchy.
.include nexor2_x0.spi
.include and2_x1.spi
.include and3_x1.spi
.include and4_x1.spi
.include nand2_x0.spi
.include or21nand_x0.spi
.include inv_x0.spi
.include dff_x1.spi
.include nand4_x0.spi
.include nor4_x0.spi
.include and21nor_x0.spi
.include nand3_x0.spi
.include or2_x1.spi
.include mux2_x1.spi
.include one_x1.spi
.include nor3_x0.spi
.include nor2_x0.spi

* Non-terminal models (part of the user's design hierarchy).

.subckt expmob2 0 1 2 3 4 5 6 7 8 9 10 11 12 13 14 15 16 17 18 19 20 21 22 23 24 25 26 27 28 29 30 31 32 33 34 35 36 37 38 39 40 41 42 43 44 45 46 47 48 49 50 51 52 53 54 55 56 57 58 59 60 61 62 63 64 65 227 228 229 230 231 232 233 234 235 236 237 238 239 240 241 242 243 244 245 246 247 248 249 250 251 252 253 254 255 256 257 258 259 260 261 262 263 264 265 266 267 268 269 270 271 272 273 274 275 276 277 278 279 280 281 282 283 284 285 286 287 288 289 290 292
* NET     0 = vss
* NET     1 = vdd
* NET     2 = outputs[9]
* NET     3 = outputs[8]
* NET     4 = outputs[7]
* NET     5 = outputs[63]
* NET     6 = outputs[62]
* NET     7 = outputs[61]
* NET     8 = outputs[60]
* NET     9 = outputs[6]
* NET    10 = outputs[59]
* NET    11 = outputs[58]
* NET    12 = outputs[57]
* NET    13 = outputs[56]
* NET    14 = outputs[55]
* NET    15 = outputs[54]
* NET    16 = outputs[53]
* NET    17 = outputs[52]
* NET    18 = outputs[51]
* NET    19 = outputs[50]
* NET    20 = outputs[5]
* NET    21 = outputs[49]
* NET    22 = outputs[48]
* NET    23 = outputs[47]
* NET    24 = outputs[46]
* NET    25 = outputs[45]
* NET    26 = outputs[44]
* NET    27 = outputs[43]
* NET    28 = outputs[42]
* NET    29 = outputs[41]
* NET    30 = outputs[40]
* NET    31 = outputs[4]
* NET    32 = outputs[39]
* NET    33 = outputs[38]
* NET    34 = outputs[37]
* NET    35 = outputs[36]
* NET    36 = outputs[35]
* NET    37 = outputs[34]
* NET    38 = outputs[33]
* NET    39 = outputs[32]
* NET    40 = outputs[31]
* NET    41 = outputs[30]
* NET    42 = outputs[3]
* NET    43 = outputs[29]
* NET    44 = outputs[28]
* NET    45 = outputs[27]
* NET    46 = outputs[26]
* NET    47 = outputs[25]
* NET    48 = outputs[24]
* NET    49 = outputs[23]
* NET    50 = outputs[22]
* NET    51 = outputs[21]
* NET    52 = outputs[20]
* NET    53 = outputs[2]
* NET    54 = outputs[19]
* NET    55 = outputs[18]
* NET    56 = outputs[17]
* NET    57 = outputs[16]
* NET    58 = outputs[15]
* NET    59 = outputs[14]
* NET    60 = outputs[13]
* NET    61 = outputs[12]
* NET    62 = outputs[11]
* NET    63 = outputs[10]
* NET    64 = outputs[1]
* NET    65 = outputs[0]
* NET    66 = one_0
* NET    67 = n0_n_31_0_9
* NET    68 = n0_n_31_0_8
* NET    69 = n0_n_31_0_7
* NET    70 = n0_n_31_0_6
* NET    71 = n0_n_31_0_5
* NET    72 = n0_n_31_0_4
* NET    73 = n0_n_31_0_31
* NET    74 = n0_n_31_0_30
* NET    75 = n0_n_31_0_3
* NET    76 = n0_n_31_0_29
* NET    77 = n0_n_31_0_28
* NET    78 = n0_n_31_0_27
* NET    79 = n0_n_31_0_26
* NET    80 = n0_n_31_0_25
* NET    81 = n0_n_31_0_24
* NET    82 = n0_n_31_0_23
* NET    83 = n0_n_31_0_22
* NET    84 = n0_n_31_0_21
* NET    85 = n0_n_31_0_20
* NET    86 = n0_n_31_0_2
* NET    87 = n0_n_31_0_19
* NET    88 = n0_n_31_0_18
* NET    89 = n0_n_31_0_17
* NET    90 = n0_n_31_0_16
* NET    91 = n0_n_31_0_15
* NET    92 = n0_n_31_0_14
* NET    93 = n0_n_31_0_13
* NET    94 = n0_n_31_0_12
* NET    95 = n0_n_31_0_11
* NET    96 = n0_n_31_0_10
* NET    97 = n0_n_31_0_1
* NET    98 = n0_n_31_0_0
* NET    99 = n0_mem_inputs_63_0_9
* NET   100 = n0_mem_inputs_63_0_8
* NET   101 = n0_mem_inputs_63_0_7
* NET   102 = n0_mem_inputs_63_0_63
* NET   103 = n0_mem_inputs_63_0_62
* NET   104 = n0_mem_inputs_63_0_61
* NET   105 = n0_mem_inputs_63_0_60
* NET   106 = n0_mem_inputs_63_0_6
* NET   107 = n0_mem_inputs_63_0_59
* NET   108 = n0_mem_inputs_63_0_58
* NET   109 = n0_mem_inputs_63_0_57
* NET   110 = n0_mem_inputs_63_0_56
* NET   111 = n0_mem_inputs_63_0_55
* NET   112 = n0_mem_inputs_63_0_54
* NET   113 = n0_mem_inputs_63_0_53
* NET   114 = n0_mem_inputs_63_0_52
* NET   115 = n0_mem_inputs_63_0_51
* NET   116 = n0_mem_inputs_63_0_50
* NET   117 = n0_mem_inputs_63_0_5
* NET   118 = n0_mem_inputs_63_0_49
* NET   119 = n0_mem_inputs_63_0_48
* NET   120 = n0_mem_inputs_63_0_47
* NET   121 = n0_mem_inputs_63_0_46
* NET   122 = n0_mem_inputs_63_0_45
* NET   123 = n0_mem_inputs_63_0_44
* NET   124 = n0_mem_inputs_63_0_43
* NET   125 = n0_mem_inputs_63_0_42
* NET   126 = n0_mem_inputs_63_0_41
* NET   127 = n0_mem_inputs_63_0_40
* NET   128 = n0_mem_inputs_63_0_4
* NET   129 = n0_mem_inputs_63_0_39
* NET   130 = n0_mem_inputs_63_0_38
* NET   131 = n0_mem_inputs_63_0_37
* NET   132 = n0_mem_inputs_63_0_36
* NET   133 = n0_mem_inputs_63_0_35
* NET   134 = n0_mem_inputs_63_0_34
* NET   135 = n0_mem_inputs_63_0_33
* NET   136 = n0_mem_inputs_63_0_32
* NET   137 = n0_mem_inputs_63_0_31
* NET   138 = n0_mem_inputs_63_0_30
* NET   139 = n0_mem_inputs_63_0_3
* NET   140 = n0_mem_inputs_63_0_29
* NET   141 = n0_mem_inputs_63_0_28
* NET   142 = n0_mem_inputs_63_0_27
* NET   143 = n0_mem_inputs_63_0_26
* NET   144 = n0_mem_inputs_63_0_25
* NET   145 = n0_mem_inputs_63_0_24
* NET   146 = n0_mem_inputs_63_0_23
* NET   147 = n0_mem_inputs_63_0_22
* NET   148 = n0_mem_inputs_63_0_21
* NET   149 = n0_mem_inputs_63_0_20
* NET   150 = n0_mem_inputs_63_0_2
* NET   151 = n0_mem_inputs_63_0_19
* NET   152 = n0_mem_inputs_63_0_18
* NET   153 = n0_mem_inputs_63_0_17
* NET   154 = n0_mem_inputs_63_0_16
* NET   155 = n0_mem_inputs_63_0_15
* NET   156 = n0_mem_inputs_63_0_14
* NET   157 = n0_mem_inputs_63_0_13
* NET   158 = n0_mem_inputs_63_0_12
* NET   159 = n0_mem_inputs_63_0_11
* NET   160 = n0_mem_inputs_63_0_10
* NET   161 = n0_mem_inputs_63_0_1
* NET   162 = n0_mem_inputs_63_0_0
* NET   163 = n[9]
* NET   164 = n[8]
* NET   165 = n[7]
* NET   166 = n[6]
* NET   167 = n[5]
* NET   168 = n[4]
* NET   169 = n[31]
* NET   170 = n[30]
* NET   171 = n[3]
* NET   172 = n[29]
* NET   173 = n[28]
* NET   174 = n[27]
* NET   175 = n[26]
* NET   176 = n[25]
* NET   177 = n[24]
* NET   178 = n[23]
* NET   179 = n[22]
* NET   180 = n[21]
* NET   181 = n[20]
* NET   182 = n[2]
* NET   183 = n[19]
* NET   184 = n[18]
* NET   185 = n[17]
* NET   186 = n[16]
* NET   187 = n[15]
* NET   188 = n[14]
* NET   189 = n[13]
* NET   190 = n[12]
* NET   191 = n[11]
* NET   192 = n[10]
* NET   193 = n[1]
* NET   194 = n[0]
* NET   195 = mem_inputs[63]
* NET   196 = mem_inputs[62]
* NET   197 = mem_inputs[61]
* NET   198 = mem_inputs[60]
* NET   199 = mem_inputs[59]
* NET   200 = mem_inputs[58]
* NET   201 = mem_inputs[57]
* NET   202 = mem_inputs[56]
* NET   203 = mem_inputs[55]
* NET   204 = mem_inputs[54]
* NET   205 = mem_inputs[53]
* NET   206 = mem_inputs[52]
* NET   207 = mem_inputs[51]
* NET   208 = mem_inputs[50]
* NET   209 = mem_inputs[49]
* NET   210 = mem_inputs[48]
* NET   211 = mem_inputs[47]
* NET   212 = mem_inputs[46]
* NET   213 = mem_inputs[45]
* NET   214 = mem_inputs[44]
* NET   215 = mem_inputs[43]
* NET   216 = mem_inputs[42]
* NET   217 = mem_inputs[41]
* NET   218 = mem_inputs[40]
* NET   219 = mem_inputs[39]
* NET   220 = mem_inputs[38]
* NET   221 = mem_inputs[37]
* NET   222 = mem_inputs[36]
* NET   223 = mem_inputs[35]
* NET   224 = mem_inputs[34]
* NET   225 = mem_inputs[33]
* NET   226 = mem_inputs[32]
* NET   227 = inputs[9]
* NET   228 = inputs[8]
* NET   229 = inputs[7]
* NET   230 = inputs[63]
* NET   231 = inputs[62]
* NET   232 = inputs[61]
* NET   233 = inputs[60]
* NET   234 = inputs[6]
* NET   235 = inputs[59]
* NET   236 = inputs[58]
* NET   237 = inputs[57]
* NET   238 = inputs[56]
* NET   239 = inputs[55]
* NET   240 = inputs[54]
* NET   241 = inputs[53]
* NET   242 = inputs[52]
* NET   243 = inputs[51]
* NET   244 = inputs[50]
* NET   245 = inputs[5]
* NET   246 = inputs[49]
* NET   247 = inputs[48]
* NET   248 = inputs[47]
* NET   249 = inputs[46]
* NET   250 = inputs[45]
* NET   251 = inputs[44]
* NET   252 = inputs[43]
* NET   253 = inputs[42]
* NET   254 = inputs[41]
* NET   255 = inputs[40]
* NET   256 = inputs[4]
* NET   257 = inputs[39]
* NET   258 = inputs[38]
* NET   259 = inputs[37]
* NET   260 = inputs[36]
* NET   261 = inputs[35]
* NET   262 = inputs[34]
* NET   263 = inputs[33]
* NET   264 = inputs[32]
* NET   265 = inputs[31]
* NET   266 = inputs[30]
* NET   267 = inputs[3]
* NET   268 = inputs[29]
* NET   269 = inputs[28]
* NET   270 = inputs[27]
* NET   271 = inputs[26]
* NET   272 = inputs[25]
* NET   273 = inputs[24]
* NET   274 = inputs[23]
* NET   275 = inputs[22]
* NET   276 = inputs[21]
* NET   277 = inputs[20]
* NET   278 = inputs[2]
* NET   279 = inputs[19]
* NET   280 = inputs[18]
* NET   281 = inputs[17]
* NET   282 = inputs[16]
* NET   283 = inputs[15]
* NET   284 = inputs[14]
* NET   285 = inputs[13]
* NET   286 = inputs[12]
* NET   287 = inputs[11]
* NET   288 = inputs[10]
* NET   289 = inputs[1]
* NET   290 = inputs[0]
* NET   291 = init
* NET   292 = clk
* NET   293 = abc_1867_new_n820
* NET   294 = abc_1867_new_n819
* NET   295 = abc_1867_new_n818
* NET   296 = abc_1867_new_n817
* NET   297 = abc_1867_new_n815
* NET   298 = abc_1867_new_n813
* NET   299 = abc_1867_new_n812
* NET   300 = abc_1867_new_n811
* NET   301 = abc_1867_new_n810
* NET   302 = abc_1867_new_n808
* NET   303 = abc_1867_new_n807
* NET   304 = abc_1867_new_n806
* NET   305 = abc_1867_new_n805
* NET   306 = abc_1867_new_n803
* NET   307 = abc_1867_new_n801
* NET   308 = abc_1867_new_n800
* NET   309 = abc_1867_new_n799
* NET   310 = abc_1867_new_n798
* NET   311 = abc_1867_new_n796
* NET   312 = abc_1867_new_n795
* NET   313 = abc_1867_new_n794
* NET   314 = abc_1867_new_n793
* NET   315 = abc_1867_new_n791
* NET   316 = abc_1867_new_n789
* NET   317 = abc_1867_new_n788
* NET   318 = abc_1867_new_n787
* NET   319 = abc_1867_new_n786
* NET   320 = abc_1867_new_n784
* NET   321 = abc_1867_new_n783
* NET   322 = abc_1867_new_n782
* NET   323 = abc_1867_new_n781
* NET   324 = abc_1867_new_n779
* NET   325 = abc_1867_new_n777
* NET   326 = abc_1867_new_n776
* NET   327 = abc_1867_new_n775
* NET   328 = abc_1867_new_n774
* NET   329 = abc_1867_new_n772
* NET   330 = abc_1867_new_n771
* NET   331 = abc_1867_new_n770
* NET   332 = abc_1867_new_n769
* NET   333 = abc_1867_new_n767
* NET   334 = abc_1867_new_n765
* NET   335 = abc_1867_new_n764
* NET   336 = abc_1867_new_n763
* NET   337 = abc_1867_new_n762
* NET   338 = abc_1867_new_n760
* NET   339 = abc_1867_new_n759
* NET   340 = abc_1867_new_n758
* NET   341 = abc_1867_new_n757
* NET   342 = abc_1867_new_n755
* NET   343 = abc_1867_new_n753
* NET   344 = abc_1867_new_n752
* NET   345 = abc_1867_new_n751
* NET   346 = abc_1867_new_n750
* NET   347 = abc_1867_new_n748
* NET   348 = abc_1867_new_n747
* NET   349 = abc_1867_new_n746
* NET   350 = abc_1867_new_n745
* NET   351 = abc_1867_new_n743
* NET   352 = abc_1867_new_n741
* NET   353 = abc_1867_new_n740
* NET   354 = abc_1867_new_n739
* NET   355 = abc_1867_new_n738
* NET   356 = abc_1867_new_n736
* NET   357 = abc_1867_new_n735
* NET   358 = abc_1867_new_n734
* NET   359 = abc_1867_new_n733
* NET   360 = abc_1867_new_n731
* NET   361 = abc_1867_new_n729
* NET   362 = abc_1867_new_n728
* NET   363 = abc_1867_new_n727
* NET   364 = abc_1867_new_n726
* NET   365 = abc_1867_new_n724
* NET   366 = abc_1867_new_n723
* NET   367 = abc_1867_new_n722
* NET   368 = abc_1867_new_n721
* NET   369 = abc_1867_new_n719
* NET   370 = abc_1867_new_n717
* NET   371 = abc_1867_new_n716
* NET   372 = abc_1867_new_n715
* NET   373 = abc_1867_new_n714
* NET   374 = abc_1867_new_n712
* NET   375 = abc_1867_new_n711
* NET   376 = abc_1867_new_n710
* NET   377 = abc_1867_new_n709
* NET   378 = abc_1867_new_n707
* NET   379 = abc_1867_new_n705
* NET   380 = abc_1867_new_n704
* NET   381 = abc_1867_new_n703
* NET   382 = abc_1867_new_n702
* NET   383 = abc_1867_new_n700
* NET   384 = abc_1867_new_n699
* NET   385 = abc_1867_new_n698
* NET   386 = abc_1867_new_n697
* NET   387 = abc_1867_new_n695
* NET   388 = abc_1867_new_n693
* NET   389 = abc_1867_new_n692
* NET   390 = abc_1867_new_n691
* NET   391 = abc_1867_new_n690
* NET   392 = abc_1867_new_n688
* NET   393 = abc_1867_new_n687
* NET   394 = abc_1867_new_n686
* NET   395 = abc_1867_new_n685
* NET   396 = abc_1867_new_n683
* NET   397 = abc_1867_new_n681
* NET   398 = abc_1867_new_n680
* NET   399 = abc_1867_new_n679
* NET   400 = abc_1867_new_n678
* NET   401 = abc_1867_new_n676
* NET   402 = abc_1867_new_n675
* NET   403 = abc_1867_new_n674
* NET   404 = abc_1867_new_n673
* NET   405 = abc_1867_new_n671
* NET   406 = abc_1867_new_n669
* NET   407 = abc_1867_new_n668
* NET   408 = abc_1867_new_n667
* NET   409 = abc_1867_new_n666
* NET   410 = abc_1867_new_n664
* NET   411 = abc_1867_new_n663
* NET   412 = abc_1867_new_n662
* NET   413 = abc_1867_new_n661
* NET   414 = abc_1867_new_n659
* NET   415 = abc_1867_new_n657
* NET   416 = abc_1867_new_n656
* NET   417 = abc_1867_new_n655
* NET   418 = abc_1867_new_n654
* NET   419 = abc_1867_new_n652
* NET   420 = abc_1867_new_n651
* NET   421 = abc_1867_new_n650
* NET   422 = abc_1867_new_n649
* NET   423 = abc_1867_new_n647
* NET   424 = abc_1867_new_n645
* NET   425 = abc_1867_new_n644
* NET   426 = abc_1867_new_n643
* NET   427 = abc_1867_new_n642
* NET   428 = abc_1867_new_n640
* NET   429 = abc_1867_new_n639
* NET   430 = abc_1867_new_n638
* NET   431 = abc_1867_new_n637
* NET   432 = abc_1867_new_n635
* NET   433 = abc_1867_new_n633
* NET   434 = abc_1867_new_n632
* NET   435 = abc_1867_new_n631
* NET   436 = abc_1867_new_n630
* NET   437 = abc_1867_new_n628
* NET   438 = abc_1867_new_n627
* NET   439 = abc_1867_new_n626
* NET   440 = abc_1867_new_n625
* NET   441 = abc_1867_new_n623
* NET   442 = abc_1867_new_n621
* NET   443 = abc_1867_new_n620
* NET   444 = abc_1867_new_n619
* NET   445 = abc_1867_new_n618
* NET   446 = abc_1867_new_n616
* NET   447 = abc_1867_new_n615
* NET   448 = abc_1867_new_n614
* NET   449 = abc_1867_new_n613
* NET   450 = abc_1867_new_n611
* NET   451 = abc_1867_new_n609
* NET   452 = abc_1867_new_n608
* NET   453 = abc_1867_new_n607
* NET   454 = abc_1867_new_n606
* NET   455 = abc_1867_new_n604
* NET   456 = abc_1867_new_n603
* NET   457 = abc_1867_new_n602
* NET   458 = abc_1867_new_n601
* NET   459 = abc_1867_new_n599
* NET   460 = abc_1867_new_n597
* NET   461 = abc_1867_new_n596
* NET   462 = abc_1867_new_n595
* NET   463 = abc_1867_new_n594
* NET   464 = abc_1867_new_n592
* NET   465 = abc_1867_new_n591
* NET   466 = abc_1867_new_n590
* NET   467 = abc_1867_new_n589
* NET   468 = abc_1867_new_n587
* NET   469 = abc_1867_new_n585
* NET   470 = abc_1867_new_n584
* NET   471 = abc_1867_new_n583
* NET   472 = abc_1867_new_n582
* NET   473 = abc_1867_new_n580
* NET   474 = abc_1867_new_n579
* NET   475 = abc_1867_new_n578
* NET   476 = abc_1867_new_n577
* NET   477 = abc_1867_new_n575
* NET   478 = abc_1867_new_n573
* NET   479 = abc_1867_new_n572
* NET   480 = abc_1867_new_n571
* NET   481 = abc_1867_new_n570
* NET   482 = abc_1867_new_n568
* NET   483 = abc_1867_new_n567
* NET   484 = abc_1867_new_n566
* NET   485 = abc_1867_new_n565
* NET   486 = abc_1867_new_n563
* NET   487 = abc_1867_new_n561
* NET   488 = abc_1867_new_n560
* NET   489 = abc_1867_new_n559
* NET   490 = abc_1867_new_n558
* NET   491 = abc_1867_new_n556
* NET   492 = abc_1867_new_n555
* NET   493 = abc_1867_new_n554
* NET   494 = abc_1867_new_n553
* NET   495 = abc_1867_new_n551
* NET   496 = abc_1867_new_n549
* NET   497 = abc_1867_new_n548
* NET   498 = abc_1867_new_n547
* NET   499 = abc_1867_new_n546
* NET   500 = abc_1867_new_n544
* NET   501 = abc_1867_new_n543
* NET   502 = abc_1867_new_n542
* NET   503 = abc_1867_new_n541
* NET   504 = abc_1867_new_n539
* NET   505 = abc_1867_new_n537
* NET   506 = abc_1867_new_n536
* NET   507 = abc_1867_new_n535
* NET   508 = abc_1867_new_n534
* NET   509 = abc_1867_new_n532
* NET   510 = abc_1867_new_n531
* NET   511 = abc_1867_new_n530
* NET   512 = abc_1867_new_n529
* NET   513 = abc_1867_new_n527
* NET   514 = abc_1867_new_n525
* NET   515 = abc_1867_new_n524
* NET   516 = abc_1867_new_n523
* NET   517 = abc_1867_new_n522
* NET   518 = abc_1867_new_n520
* NET   519 = abc_1867_new_n519
* NET   520 = abc_1867_new_n518
* NET   521 = abc_1867_new_n517
* NET   522 = abc_1867_new_n515
* NET   523 = abc_1867_new_n513
* NET   524 = abc_1867_new_n512
* NET   525 = abc_1867_new_n511
* NET   526 = abc_1867_new_n510
* NET   527 = abc_1867_new_n508
* NET   528 = abc_1867_new_n507
* NET   529 = abc_1867_new_n506
* NET   530 = abc_1867_new_n505
* NET   531 = abc_1867_new_n503
* NET   532 = abc_1867_new_n501
* NET   533 = abc_1867_new_n500
* NET   534 = abc_1867_new_n499
* NET   535 = abc_1867_new_n498
* NET   536 = abc_1867_new_n496
* NET   537 = abc_1867_new_n495
* NET   538 = abc_1867_new_n494
* NET   539 = abc_1867_new_n493
* NET   540 = abc_1867_new_n491
* NET   541 = abc_1867_new_n489
* NET   542 = abc_1867_new_n488
* NET   543 = abc_1867_new_n487
* NET   544 = abc_1867_new_n486
* NET   545 = abc_1867_new_n484
* NET   546 = abc_1867_new_n483
* NET   547 = abc_1867_new_n482
* NET   548 = abc_1867_new_n481
* NET   549 = abc_1867_new_n479
* NET   550 = abc_1867_new_n477
* NET   551 = abc_1867_new_n476
* NET   552 = abc_1867_new_n475
* NET   553 = abc_1867_new_n474
* NET   554 = abc_1867_new_n472
* NET   555 = abc_1867_new_n471
* NET   556 = abc_1867_new_n470
* NET   557 = abc_1867_new_n469
* NET   558 = abc_1867_new_n467
* NET   559 = abc_1867_new_n465
* NET   560 = abc_1867_new_n464
* NET   561 = abc_1867_new_n463
* NET   562 = abc_1867_new_n462
* NET   563 = abc_1867_new_n460
* NET   564 = abc_1867_new_n459
* NET   565 = abc_1867_new_n458
* NET   566 = abc_1867_new_n457
* NET   567 = abc_1867_new_n455
* NET   568 = abc_1867_new_n453
* NET   569 = abc_1867_new_n452
* NET   570 = abc_1867_new_n451
* NET   571 = abc_1867_new_n450
* NET   572 = abc_1867_new_n448
* NET   573 = abc_1867_new_n447
* NET   574 = abc_1867_new_n446
* NET   575 = abc_1867_new_n445
* NET   576 = abc_1867_new_n443
* NET   577 = abc_1867_new_n441
* NET   578 = abc_1867_new_n440
* NET   579 = abc_1867_new_n439
* NET   580 = abc_1867_new_n438
* NET   581 = abc_1867_new_n437
* NET   582 = abc_1867_new_n436
* NET   583 = abc_1867_new_n434
* NET   584 = abc_1867_new_n433
* NET   585 = abc_1867_new_n431
* NET   586 = abc_1867_new_n429
* NET   587 = abc_1867_new_n428
* NET   588 = abc_1867_new_n427
* NET   589 = abc_1867_new_n426
* NET   590 = abc_1867_new_n425
* NET   591 = abc_1867_new_n424
* NET   592 = abc_1867_new_n421
* NET   593 = abc_1867_new_n419
* NET   594 = abc_1867_new_n418
* NET   595 = abc_1867_new_n416
* NET   596 = abc_1867_new_n414
* NET   597 = abc_1867_new_n413
* NET   598 = abc_1867_new_n411
* NET   599 = abc_1867_new_n410
* NET   600 = abc_1867_new_n409
* NET   601 = abc_1867_new_n408
* NET   602 = abc_1867_new_n405
* NET   603 = abc_1867_new_n403
* NET   604 = abc_1867_new_n401
* NET   605 = abc_1867_new_n399
* NET   606 = abc_1867_new_n398
* NET   607 = abc_1867_new_n396
* NET   608 = abc_1867_new_n395
* NET   609 = abc_1867_new_n394
* NET   610 = abc_1867_new_n393
* NET   611 = abc_1867_new_n392
* NET   612 = abc_1867_new_n391
* NET   613 = abc_1867_new_n388
* NET   614 = abc_1867_new_n386
* NET   615 = abc_1867_new_n385
* NET   616 = abc_1867_new_n383
* NET   617 = abc_1867_new_n382
* NET   618 = abc_1867_new_n381
* NET   619 = abc_1867_new_n380
* NET   620 = abc_1867_new_n377
* NET   621 = abc_1867_new_n375
* NET   622 = abc_1867_new_n374
* NET   623 = abc_1867_new_n372
* NET   624 = abc_1867_new_n370
* NET   625 = abc_1867_new_n369
* NET   626 = abc_1867_new_n367
* NET   627 = abc_1867_new_n365
* NET   628 = abc_1867_new_n364
* NET   629 = abc_1867_new_n362
* NET   630 = abc_1867_new_n360
* NET   631 = abc_1867_new_n358
* NET   632 = abc_1867_new_n356
* NET   633 = abc_1867_new_n354
* NET   634 = abc_1867_new_n353
* NET   635 = abc_1867_new_n352
* NET   636 = abc_1867_new_n351
* NET   637 = abc_1867_new_n350
* NET   638 = abc_1867_new_n349
* NET   639 = abc_1867_new_n348
* NET   640 = abc_1867_new_n347
* NET   641 = abc_1867_new_n346
* NET   642 = abc_1867_new_n345
* NET   643 = abc_1867_new_n344
* NET   644 = abc_1867_new_n343
* NET   645 = abc_1867_new_n342
* NET   646 = abc_1867_new_n341
* NET   647 = abc_1867_new_n340
* NET   648 = abc_1867_new_n339
* NET   649 = abc_1867_new_n338
* NET   650 = abc_1867_new_n337
* NET   651 = abc_1867_new_n336
* NET   652 = abc_1867_new_n335
* NET   653 = abc_1867_new_n334
* NET   654 = abc_1867_new_n333
* NET   655 = abc_1867_new_n332
* NET   656 = abc_1867_new_n331
* NET   657 = abc_1867_new_n330
* NET   658 = abc_1867_new_n329
* NET   659 = abc_1867_new_n328
* NET   660 = abc_1867_new_n327
* NET   661 = abc_1867_new_n326
* NET   662 = abc_1867_new_n325
* NET   663 = abc_1867_new_n324
* NET   664 = abc_1867_new_n323
* NET   665 = abc_1867_new_n322
* NET   666 = abc_1867_new_n321
* NET   667 = abc_1867_new_n320
* NET   668 = abc_1867_new_n319
* NET   669 = abc_1867_new_n318
* NET   670 = abc_1867_new_n317
* NET   671 = abc_1867_new_n316
* NET   672 = abc_1867_new_n315
* NET   673 = abc_1867_new_n314
* NET   674 = abc_1867_new_n313
* NET   675 = abc_1867_new_n312
* NET   676 = abc_1867_new_n311
* NET   677 = abc_1867_new_n310
* NET   678 = abc_1867_new_n309
* NET   679 = abc_1867_new_n308
* NET   680 = abc_1867_new_n307
* NET   681 = abc_1867_new_n306
* NET   682 = abc_1867_new_n305
* NET   683 = abc_1867_new_n304
* NET   684 = abc_1867_new_n303
* NET   685 = abc_1867_new_n302
* NET   686 = abc_1867_new_n301
* NET   687 = abc_1867_new_n300
* NET   688 = abc_1867_new_n299
* NET   689 = abc_1867_new_n298
* NET   690 = abc_1867_new_n297
* NET   691 = abc_1867_new_n296
* NET   692 = abc_1867_new_n295
* NET   693 = abc_1867_new_n294
* NET   694 = abc_1867_new_n293
* NET   695 = abc_1867_new_n292
* NET   696 = abc_1867_new_n291
* NET   697 = abc_1867_new_n290

xsubckt_513_nexor2_x0 1 0 53 225 306 nexor2_x0
xsubckt_509_and2_x1 1 0 309 3 291 and2_x1
xsubckt_434_and3_x1 1 0 365 369 636 639 and3_x1
xsubckt_393_nexor2_x0 1 0 50 215 396 nexor2_x0
xsubckt_68_and4_x1 1 0 631 644 291 194 169 and4_x1
xsubckt_208_nand2_x0 1 0 535 240 668 nand2_x0
xsubckt_212_or21nand_x0 1 0 99 532 533 535 or21nand_x0
xsubckt_304_nand2_x0 1 0 463 258 668 nand2_x0
xsubckt_466_inv_x0 1 0 342 62 inv_x0
xsubckt_456_and2_x1 1 0 349 46 291 and2_x1
xsubckt_396_and2_x1 1 0 394 24 291 and2_x1
xsubckt_118_and4_x1 1 0 601 184 183 181 180 and4_x1
xsubckt_83_nexor2_x0 1 0 624 677 68 nexor2_x0
xsubckt_220_nand2_x0 1 0 526 242 668 nand2_x0
xsubckt_282_or21nand_x0 1 0 479 640 635 480 or21nand_x0
xsubckt_516_and2_x1 1 0 304 9 291 and2_x1
xsubckt_508_nand2_x0 1 0 310 256 668 nand2_x0
xsubckt_105_and3_x1 1 0 608 610 636 639 and3_x1
xsubckt_75_and4_x1 1 0 627 631 171 168 167 and4_x1
xsubckt_189_nexor2_x0 1 0 13 198 549 nexor2_x0
xsubckt_234_or21nand_x0 1 0 515 640 635 516 or21nand_x0
xsubckt_309_nexor2_x0 1 0 35 208 459 nexor2_x0
xsubckt_542_dff_x1 1 0 67 292 163 dff_x1
xsubckt_541_dff_x1 1 0 68 292 164 dff_x1
xsubckt_540_dff_x1 1 0 69 292 165 dff_x1
xsubckt_525_nexor2_x0 1 0 65 226 297 nexor2_x0
xsubckt_520_nand2_x0 1 0 301 278 668 nand2_x0
xsubckt_424_nand2_x0 1 0 373 280 668 nand2_x0
xsubckt_357_nexor2_x0 1 0 44 212 423 nexor2_x0
xsubckt_338_and3_x1 1 0 437 441 636 639 and3_x1
xsubckt_328_nand2_x0 1 0 445 262 668 nand2_x0
xsubckt_96_nand4_x0 1 0 614 615 618 631 171 nand4_x0
xsubckt_49_nor4_x0 1 0 648 175 174 173 172 nor4_x0
xsubckt_65_nexor2_x0 1 0 634 671 98 nexor2_x0
xsubckt_278_and3_x1 1 0 482 486 636 639 and3_x1
xsubckt_548_dff_x1 1 0 91 292 187 dff_x1
xsubckt_547_dff_x1 1 0 92 292 188 dff_x1
xsubckt_546_dff_x1 1 0 93 292 189 dff_x1
xsubckt_545_dff_x1 1 0 94 292 190 dff_x1
xsubckt_544_dff_x1 1 0 95 292 191 dff_x1
xsubckt_543_dff_x1 1 0 96 292 192 dff_x1
xsubckt_529_and21nor_x0 1 0 294 639 636 295 and21nor_x0
xsubckt_490_inv_x0 1 0 324 4 inv_x0
xsubckt_471_or21nand_x0 1 0 114 338 339 341 or21nand_x0
xsubckt_421_and21nor_x0 1 0 375 639 636 376 and21nor_x0
xsubckt_340_nand2_x0 1 0 436 264 668 nand2_x0
xsubckt_211_and3_x1 1 0 532 636 639 663 and3_x1
xsubckt_244_nand2_x0 1 0 508 247 668 nand2_x0
xsubckt_265_and21nor_x0 1 0 492 639 636 493 and21nor_x0
xsubckt_612_dff_x1 1 0 120 292 39 dff_x1
xsubckt_611_dff_x1 1 0 121 292 37 dff_x1
xsubckt_610_dff_x1 1 0 122 292 35 dff_x1
xsubckt_549_dff_x1 1 0 90 292 186 dff_x1
xsubckt_510_and21nor_x0 1 0 308 639 636 309 and21nor_x0
xsubckt_423_or21nand_x0 1 0 123 374 375 377 or21nand_x0
xsubckt_147_and3_x1 1 0 581 173 172 170 and3_x1
xsubckt_86_nexor2_x0 1 0 623 163 67 nexor2_x0
xsubckt_173_and2_x1 1 0 561 198 291 and2_x1
xsubckt_214_inv_x0 1 0 531 16 inv_x0
xsubckt_217_and21nor_x0 1 0 528 639 636 529 and21nor_x0
xsubckt_233_and2_x1 1 0 516 208 291 and2_x1
xsubckt_267_or21nand_x0 1 0 152 491 492 494 or21nand_x0
xsubckt_618_dff_x1 1 0 113 292 52 dff_x1
xsubckt_617_dff_x1 1 0 114 292 50 dff_x1
xsubckt_616_dff_x1 1 0 115 292 48 dff_x1
xsubckt_615_dff_x1 1 0 116 292 46 dff_x1
xsubckt_614_dff_x1 1 0 118 292 44 dff_x1
xsubckt_613_dff_x1 1 0 119 292 41 dff_x1
xsubckt_512_or21nand_x0 1 0 107 307 308 310 or21nand_x0
xsubckt_448_nand2_x0 1 0 355 284 668 nand2_x0
xsubckt_369_nexor2_x0 1 0 46 213 414 nexor2_x0
xsubckt_160_nand2_x0 1 0 571 231 668 nand2_x0
xsubckt_91_and2_x1 1 0 618 619 622 and2_x1
xsubckt_33_inv_x0 1 0 13 664 inv_x0
xsubckt_32_inv_x0 1 0 11 665 inv_x0
xsubckt_31_inv_x0 1 0 8 666 inv_x0
xsubckt_30_inv_x0 1 0 6 667 inv_x0
xsubckt_58_nand2_x0 1 0 639 641 697 nand2_x0
xsubckt_198_and21nor_x0 1 0 542 639 636 543 and21nor_x0
xsubckt_215_nand2_x0 1 0 530 241 668 nand2_x0
xsubckt_306_and21nor_x0 1 0 461 639 636 462 and21nor_x0
xsubckt_311_nand2_x0 1 0 458 259 668 nand2_x0
xsubckt_619_dff_x1 1 0 112 292 55 dff_x1
xsubckt_575_dff_x1 1 0 160 292 205 dff_x1
xsubckt_574_dff_x1 1 0 99 292 204 dff_x1
xsubckt_573_dff_x1 1 0 100 292 203 dff_x1
xsubckt_572_dff_x1 1 0 101 292 202 dff_x1
xsubckt_571_dff_x1 1 0 106 292 201 dff_x1
xsubckt_570_dff_x1 1 0 117 292 200 dff_x1
xsubckt_460_nand2_x0 1 0 346 286 668 nand2_x0
xsubckt_451_and3_x1 1 0 352 636 639 657 and3_x1
xsubckt_100_nexor2_x0 1 0 613 682 91 nexor2_x0
xsubckt_85_and4_x1 1 0 621 622 628 631 171 and4_x1
xsubckt_39_inv_x0 1 0 55 658 inv_x0
xsubckt_38_inv_x0 1 0 50 659 inv_x0
xsubckt_37_inv_x0 1 0 46 660 inv_x0
xsubckt_36_inv_x0 1 0 35 661 inv_x0
xsubckt_35_inv_x0 1 0 33 662 inv_x0
xsubckt_34_inv_x0 1 0 15 663 inv_x0
xsubckt_180_and2_x1 1 0 556 199 291 and2_x1
xsubckt_200_or21nand_x0 1 0 101 541 542 544 or21nand_x0
xsubckt_219_or21nand_x0 1 0 160 527 528 530 or21nand_x0
xsubckt_240_and2_x1 1 0 511 209 291 and2_x1
xsubckt_308_or21nand_x0 1 0 144 460 461 463 or21nand_x0
xsubckt_579_dff_x1 1 0 156 292 209 dff_x1
xsubckt_578_dff_x1 1 0 157 292 208 dff_x1
xsubckt_577_dff_x1 1 0 158 292 207 dff_x1
xsubckt_576_dff_x1 1 0 159 292 206 dff_x1
xsubckt_515_nand2_x0 1 0 305 267 668 nand2_x0
xsubckt_511_and3_x1 1 0 307 636 639 655 and3_x1
xsubckt_419_nand2_x0 1 0 377 279 668 nand2_x0
xsubckt_364_nand2_x0 1 0 418 269 668 nand2_x0
xsubckt_72_and3_x1 1 0 629 631 171 168 and3_x1
xsubckt_178_inv_x0 1 0 558 10 inv_x0
xsubckt_223_nand3_x0 1 0 523 636 639 17 nand3_x0
xsubckt_268_nand2_x0 1 0 490 251 668 nand2_x0
xsubckt_270_or21nand_x0 1 0 488 640 635 489 or21nand_x0
xsubckt_300_and2_x1 1 0 466 219 291 and2_x1
xsubckt_473_and2_x1 1 0 336 52 291 and2_x1
xsubckt_431_nand2_x0 1 0 368 281 668 nand2_x0
xsubckt_335_nand2_x0 1 0 440 263 668 nand2_x0
xsubckt_130_nexor2_x0 1 0 595 691 80 nexor2_x0
xsubckt_89_nexor2_x0 1 0 620 679 95 nexor2_x0
xsubckt_184_nand2_x0 1 0 553 236 668 nand2_x0
xsubckt_222_or21nand_x0 1 0 524 640 635 525 or21nand_x0
xsubckt_239_nand2_x0 1 0 512 246 668 nand2_x0
xsubckt_280_nand2_x0 1 0 481 253 668 nand2_x0
xsubckt_523_nand3_x0 1 0 298 636 639 53 nand3_x0
xsubckt_112_nexor2_x0 1 0 605 685 88 nexor2_x0
xsubckt_251_nand2_x0 1 0 503 248 668 nand2_x0
xsubckt_310_inv_x0 1 0 459 34 inv_x0
xsubckt_517_and21nor_x0 1 0 303 639 636 304 and21nor_x0
xsubckt_484_nand2_x0 1 0 328 228 668 nand2_x0
xsubckt_480_and2_x1 1 0 331 55 291 and2_x1
xsubckt_388_nand2_x0 1 0 400 273 668 nand2_x0
xsubckt_343_nand3_x0 1 0 433 636 639 39 nand3_x0
xsubckt_155_nand2_x0 1 0 575 230 668 nand2_x0
xsubckt_141_nand4_x0 1 0 585 587 636 639 172 nand4_x0
xsubckt_204_and2_x1 1 0 538 203 291 and2_x1
xsubckt_247_nand3_x0 1 0 505 636 639 22 nand3_x0
xsubckt_519_or21nand_x0 1 0 105 302 303 305 or21nand_x0
xsubckt_500_nand3_x0 1 0 109 316 317 319 nand3_x0
xsubckt_455_nand2_x0 1 0 350 285 668 nand2_x0
xsubckt_411_or21nand_x0 1 0 125 383 384 386 or21nand_x0
xsubckt_377_and2_x1 1 0 408 17 291 and2_x1
xsubckt_142_nexor2_x0 1 0 586 695 76 nexor2_x0
xsubckt_253_and21nor_x0 1 0 501 639 636 502 and21nor_x0
xsubckt_274_inv_x0 1 0 486 27 inv_x0
xsubckt_437_and2_x1 1 0 363 39 291 and2_x1
xsubckt_422_and3_x1 1 0 374 378 636 639 and3_x1
xsubckt_362_and3_x1 1 0 419 423 636 639 and3_x1
xsubckt_359_nand2_x0 1 0 422 268 668 nand2_x0
xsubckt_133_nexor2_x0 1 0 592 693 78 nexor2_x0
xsubckt_186_and21nor_x0 1 0 551 639 636 552 and21nor_x0
xsubckt_205_and21nor_x0 1 0 537 639 636 538 and21nor_x0
xsubckt_224_nand3_x0 1 0 159 523 524 526 nand3_x0
xsubckt_255_or21nand_x0 1 0 154 500 501 503 or21nand_x0
xsubckt_463_nand3_x0 1 0 343 636 639 61 nand3_x0
xsubckt_384_and2_x1 1 0 403 19 291 and2_x1
xsubckt_371_nand2_x0 1 0 413 270 668 nand2_x0
xsubckt_179_nand2_x0 1 0 557 235 668 nand2_x0
xsubckt_188_or21nand_x0 1 0 117 550 551 553 or21nand_x0
xsubckt_199_and3_x1 1 0 541 636 639 664 and3_x1
xsubckt_207_or21nand_x0 1 0 100 536 537 539 or21nand_x0
xsubckt_275_nand2_x0 1 0 485 252 668 nand2_x0
xsubckt_319_and3_x1 1 0 451 636 639 661 and3_x1
xsubckt_524_nand3_x0 1 0 104 298 299 301 nand3_x0
xsubckt_522_or21nand_x0 1 0 299 640 635 300 or21nand_x0
xsubckt_504_and2_x1 1 0 313 63 291 and2_x1
xsubckt_444_and2_x1 1 0 358 41 291 and2_x1
xsubckt_367_nand3_x0 1 0 415 636 639 44 nand3_x0
xsubckt_346_inv_x0 1 0 432 40 inv_x0
xsubckt_108_and2_x1 1 0 606 186 185 and2_x1
xsubckt_106_and4_x1 1 0 607 610 636 639 186 and4_x1
xsubckt_191_nand2_x0 1 0 548 237 668 nand2_x0
xsubckt_479_nand2_x0 1 0 332 227 668 nand2_x0
xsubckt_440_nand3_x0 1 0 120 361 362 364 nand3_x0
xsubckt_366_or21nand_x0 1 0 416 640 635 417 or21nand_x0
xsubckt_326_and3_x1 1 0 446 450 636 639 and3_x1
xsubckt_266_and3_x1 1 0 491 495 636 639 and3_x1
xsubckt_283_nand3_x0 1 0 478 636 639 28 nand3_x0
xsubckt_491_nand2_x0 1 0 323 229 668 nand2_x0
xsubckt_418_inv_x0 1 0 378 54 inv_x0
xsubckt_395_nand2_x0 1 0 395 274 668 nand2_x0
xsubckt_370_inv_x0 1 0 414 45 inv_x0
xsubckt_344_nand3_x0 1 0 137 433 434 436 nand3_x0
xsubckt_127_nexor2_x0 1 0 596 690 81 nexor2_x0
xsubckt_4_inv_x0 1 0 174 693 inv_x0
xsubckt_3_inv_x0 1 0 173 694 inv_x0
xsubckt_2_inv_x0 1 0 172 695 inv_x0
xsubckt_1_inv_x0 1 0 170 696 inv_x0
xsubckt_0_inv_x0 1 0 169 697 inv_x0
xsubckt_248_nand3_x0 1 0 155 505 506 508 nand3_x0
xsubckt_299_nand2_x0 1 0 467 257 668 nand2_x0
xsubckt_505_and21nor_x0 1 0 312 639 636 313 and21nor_x0
xsubckt_487_nand3_x0 1 0 325 636 639 3 nand3_x0
xsubckt_397_and21nor_x0 1 0 393 639 636 394 and21nor_x0
xsubckt_348_and2_x1 1 0 430 6 291 and2_x1
xsubckt_109_and4_x1 1 0 605 606 610 636 639 and4_x1
xsubckt_9_inv_x0 1 0 179 688 inv_x0
xsubckt_8_inv_x0 1 0 178 689 inv_x0
xsubckt_7_inv_x0 1 0 177 690 inv_x0
xsubckt_6_inv_x0 1 0 176 691 inv_x0
xsubckt_5_inv_x0 1 0 175 692 inv_x0
xsubckt_44_nor4_x0 1 0 653 188 187 186 185 nor4_x0
xsubckt_161_and2_x1 1 0 570 196 291 and2_x1
xsubckt_260_nand3_x0 1 0 153 496 497 499 nand3_x0
xsubckt_288_and2_x1 1 0 475 217 291 and2_x1
xsubckt_507_or21nand_x0 1 0 108 311 312 314 or21nand_x0
xsubckt_408_and2_x1 1 0 385 28 291 and2_x1
xsubckt_399_or21nand_x0 1 0 127 392 393 395 or21nand_x0
xsubckt_349_and21nor_x0 1 0 429 639 636 430 and21nor_x0
xsubckt_92_and3_x1 1 0 617 618 631 171 and3_x1
xsubckt_66_and4_x1 1 0 632 639 291 194 193 and4_x1
xsubckt_221_and2_x1 1 0 525 206 291 and2_x1
xsubckt_241_and21nor_x0 1 0 510 639 636 511 and21nor_x0
xsubckt_291_or21nand_x0 1 0 147 473 474 476 or21nand_x0
xsubckt_464_nand3_x0 1 0 115 343 344 346 nand3_x0
xsubckt_442_inv_x0 1 0 360 58 inv_x0
xsubckt_380_or21nand_x0 1 0 131 406 407 409 or21nand_x0
xsubckt_368_nand3_x0 1 0 133 415 416 418 nand3_x0
xsubckt_104_nand2_x0 1 0 609 611 618 nand2_x0
xsubckt_81_nexor2_x0 1 0 626 676 69 nexor2_x0
xsubckt_51_nor4_x0 1 0 646 184 183 181 180 nor4_x0
xsubckt_174_and21nor_x0 1 0 560 639 636 561 and21nor_x0
xsubckt_243_or21nand_x0 1 0 156 509 510 512 or21nand_x0
xsubckt_176_or21nand_x0 1 0 139 559 560 562 or21nand_x0
xsubckt_201_nexor2_x0 1 0 15 199 540 nexor2_x0
xsubckt_284_nand3_x0 1 0 148 478 479 481 nand3_x0
xsubckt_514_inv_x0 1 0 306 42 inv_x0
xsubckt_461_and2_x1 1 0 345 48 291 and2_x1
xsubckt_521_and2_x1 1 0 300 31 291 and2_x1
xsubckt_488_nand3_x0 1 0 111 325 326 328 nand3_x0
xsubckt_354_or21nand_x0 1 0 425 640 635 426 or21nand_x0
xsubckt_478_inv_x0 1 0 333 2 inv_x0
xsubckt_403_and3_x1 1 0 388 636 639 659 and3_x1
xsubckt_385_and21nor_x0 1 0 402 639 636 403 and21nor_x0
xsubckt_10_inv_x0 1 0 181 687 inv_x0
xsubckt_11_inv_x0 1 0 183 686 inv_x0
xsubckt_12_inv_x0 1 0 184 685 inv_x0
xsubckt_13_inv_x0 1 0 185 684 inv_x0
xsubckt_14_inv_x0 1 0 186 683 inv_x0
xsubckt_213_nexor2_x0 1 0 17 200 531 nexor2_x0
xsubckt_261_nexor2_x0 1 0 26 204 495 nexor2_x0
xsubckt_555_dff_x1 1 0 83 292 179 dff_x1
xsubckt_554_dff_x1 1 0 84 292 180 dff_x1
xsubckt_553_dff_x1 1 0 85 292 181 dff_x1
xsubckt_552_dff_x1 1 0 87 292 183 dff_x1
xsubckt_551_dff_x1 1 0 88 292 184 dff_x1
xsubckt_550_dff_x1 1 0 89 292 185 dff_x1
xsubckt_474_and21nor_x0 1 0 335 639 636 336 and21nor_x0
xsubckt_425_and2_x1 1 0 372 35 291 and2_x1
xsubckt_410_and3_x1 1 0 383 387 636 639 and3_x1
xsubckt_387_or21nand_x0 1 0 130 401 402 404 or21nand_x0
xsubckt_365_and2_x1 1 0 417 13 291 and2_x1
xsubckt_350_and3_x1 1 0 428 432 636 639 and3_x1
xsubckt_337_and21nor_x0 1 0 438 639 636 439 and21nor_x0
xsubckt_154_inv_x0 1 0 576 5 inv_x0
xsubckt_128_and2_x1 1 0 594 177 176 and2_x1
xsubckt_126_and4_x1 1 0 595 597 600 608 177 and4_x1
xsubckt_113_and3_x1 1 0 603 605 184 183 and3_x1
xsubckt_98_and3_x1 1 0 613 616 189 188 and3_x1
xsubckt_15_inv_x0 1 0 187 682 inv_x0
xsubckt_16_inv_x0 1 0 189 681 inv_x0
xsubckt_17_inv_x0 1 0 190 680 inv_x0
xsubckt_18_inv_x0 1 0 191 679 inv_x0
xsubckt_19_inv_x0 1 0 192 678 inv_x0
xsubckt_290_and3_x1 1 0 473 477 636 639 and3_x1
xsubckt_559_dff_x1 1 0 79 292 175 dff_x1
xsubckt_558_dff_x1 1 0 80 292 176 dff_x1
xsubckt_557_dff_x1 1 0 81 292 177 dff_x1
xsubckt_556_dff_x1 1 0 82 292 178 dff_x1
xsubckt_476_or21nand_x0 1 0 113 334 335 337 or21nand_x0
xsubckt_426_and21nor_x0 1 0 371 639 636 372 and21nor_x0
xsubckt_339_or21nand_x0 1 0 138 437 438 440 or21nand_x0
xsubckt_162_and21nor_x0 1 0 569 639 636 570 and21nor_x0
xsubckt_187_and3_x1 1 0 550 636 639 665 and3_x1
xsubckt_231_or21nand_x0 1 0 158 518 519 521 or21nand_x0
xsubckt_625_dff_x1 1 0 105 292 9 dff_x1
xsubckt_624_dff_x1 1 0 107 292 3 dff_x1
xsubckt_623_dff_x1 1 0 108 292 63 dff_x1
xsubckt_622_dff_x1 1 0 109 292 61 dff_x1
xsubckt_621_dff_x1 1 0 110 292 59 dff_x1
xsubckt_620_dff_x1 1 0 111 292 57 dff_x1
xsubckt_432_and2_x1 1 0 367 37 291 and2_x1
xsubckt_428_or21nand_x0 1 0 122 370 371 373 or21nand_x0
xsubckt_372_and2_x1 1 0 412 15 291 and2_x1
xsubckt_150_nand4_x0 1 0 578 584 589 173 169 nand4_x0
xsubckt_135_and2_x1 1 0 590 591 597 and2_x1
xsubckt_90_and4_x1 1 0 619 168 167 192 191 and4_x1
xsubckt_40_inv_x0 1 0 59 657 inv_x0
xsubckt_164_or21nand_x0 1 0 161 568 569 571 or21nand_x0
xsubckt_225_nexor2_x0 1 0 19 201 522 nexor2_x0
xsubckt_226_inv_x0 1 0 522 18 inv_x0
xsubckt_273_nexor2_x0 1 0 28 205 486 nexor2_x0
xsubckt_307_and3_x1 1 0 460 636 639 662 and3_x1
xsubckt_320_or21nand_x0 1 0 142 451 452 454 or21nand_x0
xsubckt_629_dff_x1 1 0 66 292 291 dff_x1
xsubckt_628_dff_x1 1 0 102 292 65 dff_x1
xsubckt_627_dff_x1 1 0 103 292 53 dff_x1
xsubckt_626_dff_x1 1 0 104 292 31 dff_x1
xsubckt_582_dff_x1 1 0 153 292 212 dff_x1
xsubckt_581_dff_x1 1 0 154 292 211 dff_x1
xsubckt_580_dff_x1 1 0 155 292 210 dff_x1
xsubckt_498_or21nand_x0 1 0 317 640 635 318 or21nand_x0
xsubckt_441_nexor2_x0 1 0 59 219 360 nexor2_x0
xsubckt_390_or21nand_x0 1 0 398 640 635 399 or21nand_x0
xsubckt_152_or2_x1 1 0 73 577 582 or2_x1
xsubckt_115_nand4_x0 1 0 602 605 184 183 181 nand4_x0
xsubckt_110_nexor2_x0 1 0 607 684 89 nexor2_x0
xsubckt_41_inv_x0 1 0 63 656 inv_x0
xsubckt_42_inv_x0 1 0 31 655 inv_x0
xsubckt_53_and2_x1 1 0 644 182 193 and2_x1
xsubckt_69_nexor2_x0 1 0 632 670 86 nexor2_x0
xsubckt_78_nexor2_x0 1 0 627 675 70 nexor2_x0
xsubckt_194_and3_x1 1 0 545 549 636 639 and3_x1
xsubckt_254_and3_x1 1 0 500 504 636 639 and3_x1
xsubckt_269_and2_x1 1 0 489 214 291 and2_x1
xsubckt_588_dff_x1 1 0 146 292 218 dff_x1
xsubckt_587_dff_x1 1 0 147 292 217 dff_x1
xsubckt_586_dff_x1 1 0 148 292 216 dff_x1
xsubckt_585_dff_x1 1 0 149 292 215 dff_x1
xsubckt_584_dff_x1 1 0 151 292 214 dff_x1
xsubckt_583_dff_x1 1 0 152 292 213 dff_x1
xsubckt_342_or21nand_x0 1 0 434 640 635 435 or21nand_x0
xsubckt_329_and2_x1 1 0 444 224 291 and2_x1
xsubckt_103_and2_x1 1 0 610 611 618 and2_x1
xsubckt_47_and4_x1 1 0 650 651 652 653 654 and4_x1
xsubckt_314_and3_x1 1 0 455 459 636 639 and3_x1
xsubckt_589_dff_x1 1 0 145 292 219 dff_x1
xsubckt_140_nexor2_x0 1 0 588 694 77 nexor2_x0
xsubckt_138_and2_x1 1 0 587 589 173 and2_x1
xsubckt_136_and4_x1 1 0 589 590 600 611 618 and4_x1
xsubckt_99_nexor2_x0 1 0 614 188 92 nexor2_x0
xsubckt_82_nand3_x0 1 0 623 626 165 164 nand3_x0
xsubckt_237_nexor2_x0 1 0 22 202 513 nexor2_x0
xsubckt_250_inv_x0 1 0 504 23 inv_x0
xsubckt_276_and2_x1 1 0 484 215 291 and2_x1
xsubckt_285_nexor2_x0 1 0 30 206 477 nexor2_x0
xsubckt_453_nexor2_x0 1 0 61 220 351 nexor2_x0
xsubckt_405_nexor2_x0 1 0 52 216 387 nexor2_x0
xsubckt_373_and21nor_x0 1 0 411 639 636 412 and21nor_x0
xsubckt_336_and2_x1 1 0 439 225 291 and2_x1
xsubckt_122_nexor2_x0 1 0 599 688 83 nexor2_x0
xsubckt_95_and2_x1 1 0 615 190 189 and2_x1
xsubckt_93_and4_x1 1 0 616 618 631 171 190 and4_x1
xsubckt_531_or21nand_x0 1 0 103 293 294 296 or21nand_x0
xsubckt_494_and3_x1 1 0 320 324 636 639 and3_x1
xsubckt_412_nand2_x0 1 0 382 277 668 nand2_x0
xsubckt_375_or21nand_x0 1 0 132 410 411 413 or21nand_x0
xsubckt_325_and21nor_x0 1 0 447 639 636 448 and21nor_x0
xsubckt_322_inv_x0 1 0 450 36 inv_x0
xsubckt_158_and3_x1 1 0 572 576 636 639 and3_x1
xsubckt_149_or21nand_x0 1 0 579 580 609 697 or21nand_x0
xsubckt_218_and3_x1 1 0 527 531 636 639 and3_x1
xsubckt_316_nand2_x0 1 0 454 260 668 nand2_x0
xsubckt_327_or21nand_x0 1 0 141 446 447 449 or21nand_x0
xsubckt_63_and2_x1 1 0 634 636 639 and2_x1
xsubckt_169_and21nor_x0 1 0 564 639 636 565 and21nor_x0
xsubckt_249_nexor2_x0 1 0 24 203 504 nexor2_x0
xsubckt_465_nexor2_x0 1 0 63 221 342 nexor2_x0
xsubckt_417_nexor2_x0 1 0 55 217 378 nexor2_x0
xsubckt_232_nand2_x0 1 0 517 244 668 nand2_x0
xsubckt_286_inv_x0 1 0 477 29 inv_x0
xsubckt_297_nexor2_x0 1 0 33 207 468 nexor2_x0
xsubckt_486_or21nand_x0 1 0 326 640 635 327 or21nand_x0
xsubckt_398_and3_x1 1 0 392 396 636 639 and3_x1
xsubckt_125_nexor2_x0 1 0 598 689 82 nexor2_x0
xsubckt_59_and2_x1 1 0 638 644 671 and2_x1
xsubckt_70_and2_x1 1 0 630 631 171 and2_x1
xsubckt_203_nand2_x0 1 0 539 239 668 nand2_x0
xsubckt_532_mux2_x1 1 0 290 65 291 102 mux2_x1
xsubckt_518_and3_x1 1 0 302 306 636 639 and3_x1
xsubckt_458_and3_x1 1 0 347 351 636 639 and3_x1
xsubckt_438_or21nand_x0 1 0 362 640 635 363 or21nand_x0
xsubckt_436_nand2_x0 1 0 364 282 668 nand2_x0
xsubckt_330_or21nand_x0 1 0 443 640 635 444 or21nand_x0
xsubckt_116_nexor2_x0 1 0 603 687 85 nexor2_x0
xsubckt_107_nexor2_x0 1 0 608 683 90 nexor2_x0
xsubckt_503_nand2_x0 1 0 314 245 668 nand2_x0
xsubckt_477_nexor2_x0 1 0 3 222 333 nexor2_x0
xsubckt_429_nexor2_x0 1 0 57 218 369 nexor2_x0
xsubckt_407_nand2_x0 1 0 386 276 668 nand2_x0
xsubckt_358_inv_x0 1 0 423 43 inv_x0
xsubckt_352_nand2_x0 1 0 427 266 668 nand2_x0
xsubckt_120_and2_x1 1 0 599 600 608 and2_x1
xsubckt_256_nand2_x0 1 0 499 249 668 nand2_x0
xsubckt_469_and21nor_x0 1 0 339 639 636 340 and21nor_x0
xsubckt_361_and21nor_x0 1 0 420 639 636 421 and21nor_x0
xsubckt_353_and2_x1 1 0 426 8 291 and2_x1
xsubckt_323_nand2_x0 1 0 449 261 668 nand2_x0
xsubckt_60_nand3_x0 1 0 637 638 645 650 nand3_x0
xsubckt_172_nand2_x0 1 0 562 233 668 nand2_x0
xsubckt_293_and2_x1 1 0 471 218 291 and2_x1
xsubckt_450_and21nor_x0 1 0 353 639 636 354 and21nor_x0
xsubckt_415_nand3_x0 1 0 379 636 639 52 nand3_x0
xsubckt_413_and2_x1 1 0 381 30 291 and2_x1
xsubckt_382_inv_x0 1 0 405 47 inv_x0
xsubckt_363_or21nand_x0 1 0 134 419 420 422 or21nand_x0
xsubckt_101_and3_x1 1 0 612 171 188 187 and3_x1
xsubckt_175_and3_x1 1 0 559 636 639 666 and3_x1
xsubckt_227_nand2_x0 1 0 521 243 668 nand2_x0
xsubckt_313_and21nor_x0 1 0 456 639 636 457 and21nor_x0
xsubckt_527_nand2_x0 1 0 296 289 668 nand2_x0
xsubckt_489_nexor2_x0 1 0 9 223 324 nexor2_x0
xsubckt_472_nand2_x0 1 0 337 288 668 nand2_x0
xsubckt_452_or21nand_x0 1 0 118 352 353 355 or21nand_x0
xsubckt_402_and21nor_x0 1 0 389 639 636 390 and21nor_x0
xsubckt_376_nand2_x0 1 0 409 271 668 nand2_x0
xsubckt_360_and2_x1 1 0 421 11 291 and2_x1
xsubckt_331_nand3_x0 1 0 442 636 639 37 nand3_x0
xsubckt_157_and21nor_x0 1 0 573 639 636 574 and21nor_x0
xsubckt_123_and2_x1 1 0 597 179 178 and2_x1
xsubckt_315_or21nand_x0 1 0 143 455 456 458 or21nand_x0
xcmpt_one_0 1 0 66 one_x1
xsubckt_420_and2_x1 1 0 376 33 291 and2_x1
xsubckt_404_or21nand_x0 1 0 126 388 389 391 or21nand_x0
xsubckt_159_or21nand_x0 1 0 162 572 573 575 or21nand_x0
xsubckt_54_and3_x1 1 0 643 182 194 193 and3_x1
xsubckt_80_and2_x1 1 0 624 625 627 and2_x1
xsubckt_182_and3_x1 1 0 554 558 636 639 and3_x1
xsubckt_197_and2_x1 1 0 543 202 291 and2_x1
xsubckt_235_nand3_x0 1 0 514 636 639 19 nand3_x0
xsubckt_292_nand2_x0 1 0 472 255 668 nand2_x0
xsubckt_454_inv_x0 1 0 351 60 inv_x0
xsubckt_443_nand2_x0 1 0 359 283 668 nand2_x0
xsubckt_347_nand2_x0 1 0 431 265 668 nand2_x0
xsubckt_119_and2_x1 1 0 600 601 606 and2_x1
xsubckt_196_nand2_x0 1 0 544 238 668 nand2_x0
xsubckt_242_and3_x1 1 0 509 513 636 639 and3_x1
xsubckt_257_and2_x1 1 0 498 212 291 and2_x1
xsubckt_302_and3_x1 1 0 464 468 636 639 and3_x1
xsubckt_317_and2_x1 1 0 453 222 291 and2_x1
xsubckt_496_nand2_x0 1 0 319 234 668 nand2_x0
xsubckt_475_and3_x1 1 0 334 636 639 656 and3_x1
xsubckt_439_nand3_x0 1 0 361 636 639 57 nand3_x0
xsubckt_139_and3_x1 1 0 586 587 636 639 and3_x1
xsubckt_55_nand3_x0 1 0 642 182 194 193 nand3_x0
xsubckt_73_nexor2_x0 1 0 630 673 72 nexor2_x0
xsubckt_167_nand2_x0 1 0 566 232 668 nand2_x0
xsubckt_263_nand2_x0 1 0 494 250 668 nand2_x0
xsubckt_535_dff_x1 1 0 86 292 182 dff_x1
xsubckt_534_dff_x1 1 0 97 292 193 dff_x1
xsubckt_533_dff_x1 1 0 98 292 194 dff_x1
xsubckt_526_inv_x0 1 0 297 64 inv_x0
xsubckt_355_nand3_x0 1 0 424 636 639 41 nand3_x0
xsubckt_324_and2_x1 1 0 448 223 291 and2_x1
xsubckt_124_and4_x1 1 0 596 600 608 179 178 and4_x1
xsubckt_259_nand3_x0 1 0 496 636 639 24 nand3_x0
xsubckt_264_and2_x1 1 0 493 213 291 and2_x1
xsubckt_539_dff_x1 1 0 70 292 166 dff_x1
xsubckt_538_dff_x1 1 0 71 292 167 dff_x1
xsubckt_537_dff_x1 1 0 72 292 168 dff_x1
xsubckt_536_dff_x1 1 0 75 292 171 dff_x1
xsubckt_497_and2_x1 1 0 318 61 291 and2_x1
xsubckt_482_and3_x1 1 0 329 333 636 639 and3_x1
xsubckt_467_nand2_x0 1 0 341 287 668 nand2_x0
xsubckt_457_and21nor_x0 1 0 348 639 636 349 and21nor_x0
xsubckt_416_nand3_x0 1 0 124 379 380 382 nand3_x0
xsubckt_94_nexor2_x0 1 0 617 680 94 nexor2_x0
xsubckt_271_nand3_x0 1 0 487 636 639 26 nand3_x0
xsubckt_605_dff_x1 1 0 127 292 24 dff_x1
xsubckt_604_dff_x1 1 0 129 292 22 dff_x1
xsubckt_603_dff_x1 1 0 130 292 19 dff_x1
xsubckt_602_dff_x1 1 0 131 292 17 dff_x1
xsubckt_601_dff_x1 1 0 132 292 15 dff_x1
xsubckt_600_dff_x1 1 0 133 292 13 dff_x1
xsubckt_459_or21nand_x0 1 0 116 347 348 350 or21nand_x0
xsubckt_409_and21nor_x0 1 0 384 639 636 385 and21nor_x0
xsubckt_383_nand2_x0 1 0 404 272 668 nand2_x0
xsubckt_351_or21nand_x0 1 0 136 428 429 431 or21nand_x0
xsubckt_332_nand3_x0 1 0 140 442 443 445 nand3_x0
xsubckt_21_inv_x0 1 0 165 676 inv_x0
xsubckt_20_inv_x0 1 0 164 677 inv_x0
xsubckt_64_and3_x1 1 0 633 639 291 194 and3_x1
xsubckt_76_nexor2_x0 1 0 629 674 71 nexor2_x0
xsubckt_77_and4_x1 1 0 626 628 631 171 166 and4_x1
xsubckt_79_and2_x1 1 0 625 166 165 and2_x1
xsubckt_193_and21nor_x0 1 0 546 639 636 547 and21nor_x0
xsubckt_202_inv_x0 1 0 540 14 inv_x0
xsubckt_206_and3_x1 1 0 536 540 636 639 and3_x1
xsubckt_236_nand3_x0 1 0 157 514 515 517 nand3_x0
xsubckt_301_and21nor_x0 1 0 465 639 636 466 and21nor_x0
xsubckt_609_dff_x1 1 0 123 292 33 dff_x1
xsubckt_608_dff_x1 1 0 124 292 30 dff_x1
xsubckt_607_dff_x1 1 0 125 292 28 dff_x1
xsubckt_606_dff_x1 1 0 126 292 26 dff_x1
xsubckt_562_dff_x1 1 0 76 292 172 dff_x1
xsubckt_561_dff_x1 1 0 77 292 173 dff_x1
xsubckt_560_dff_x1 1 0 78 292 174 dff_x1
xsubckt_379_and3_x1 1 0 406 636 639 660 and3_x1
xsubckt_145_and21nor_x0 1 0 74 696 585 583 and21nor_x0
xsubckt_129_and2_x1 1 0 593 594 596 and2_x1
xsubckt_26_inv_x0 1 0 194 671 inv_x0
xsubckt_25_inv_x0 1 0 193 672 inv_x0
xsubckt_24_inv_x0 1 0 168 673 inv_x0
xsubckt_23_inv_x0 1 0 167 674 inv_x0
xsubckt_22_inv_x0 1 0 166 675 inv_x0
xsubckt_67_nexor2_x0 1 0 633 672 97 nexor2_x0
xsubckt_168_and2_x1 1 0 565 197 291 and2_x1
xsubckt_195_or21nand_x0 1 0 106 545 546 548 or21nand_x0
xsubckt_228_and2_x1 1 0 520 207 291 and2_x1
xsubckt_287_nand2_x0 1 0 476 254 668 nand2_x0
xsubckt_568_dff_x1 1 0 139 292 198 dff_x1
xsubckt_567_dff_x1 1 0 150 292 197 dff_x1
xsubckt_566_dff_x1 1 0 161 292 196 dff_x1
xsubckt_565_dff_x1 1 0 162 292 195 dff_x1
xsubckt_564_dff_x1 1 0 73 292 169 dff_x1
xsubckt_563_dff_x1 1 0 74 292 170 dff_x1
xsubckt_391_nand3_x0 1 0 397 636 639 48 nand3_x0
xsubckt_84_and4_x1 1 0 622 166 165 164 163 and4_x1
xsubckt_29_inv_x0 1 0 291 668 inv_x0
xsubckt_28_inv_x0 1 0 171 669 inv_x0
xsubckt_27_inv_x0 1 0 182 670 inv_x0
xsubckt_166_inv_x0 1 0 567 7 inv_x0
xsubckt_303_or21nand_x0 1 0 145 464 465 467 or21nand_x0
xsubckt_569_dff_x1 1 0 128 292 199 dff_x1
xsubckt_462_or21nand_x0 1 0 344 640 635 345 or21nand_x0
xsubckt_446_and3_x1 1 0 356 360 636 639 and3_x1
xsubckt_386_and3_x1 1 0 401 405 636 639 and3_x1
xsubckt_356_nand3_x0 1 0 135 424 425 427 nand3_x0
xsubckt_134_and4_x1 1 0 591 177 176 175 174 and4_x1
xsubckt_97_nexor2_x0 1 0 616 681 93 nexor2_x0
xsubckt_45_nor3_x0 1 0 652 171 168 167 nor3_x0
xsubckt_56_nand3_x0 1 0 641 642 645 650 nand3_x0
xsubckt_295_nand3_x0 1 0 469 636 639 30 nand3_x0
xsubckt_506_and3_x1 1 0 311 315 636 639 and3_x1
xsubckt_414_or21nand_x0 1 0 380 640 635 381 or21nand_x0
xsubckt_121_and3_x1 1 0 598 600 608 179 and3_x1
xsubckt_88_nexor2_x0 1 0 621 678 96 nexor2_x0
xsubckt_52_and4_x1 1 0 645 646 647 648 649 and4_x1
xsubckt_190_inv_x0 1 0 549 12 inv_x0
xsubckt_238_inv_x0 1 0 513 21 inv_x0
xsubckt_595_dff_x1 1 0 138 292 225 dff_x1
xsubckt_594_dff_x1 1 0 140 292 224 dff_x1
xsubckt_593_dff_x1 1 0 141 292 223 dff_x1
xsubckt_592_dff_x1 1 0 142 292 222 dff_x1
xsubckt_591_dff_x1 1 0 143 292 221 dff_x1
xsubckt_590_dff_x1 1 0 144 292 220 dff_x1
xsubckt_528_and2_x1 1 0 295 53 291 and2_x1
xsubckt_499_nand3_x0 1 0 316 636 639 9 nand3_x0
xsubckt_468_and2_x1 1 0 340 50 291 and2_x1
xsubckt_143_and2_x1 1 0 584 172 170 and2_x1
xsubckt_258_or21nand_x0 1 0 497 640 635 498 or21nand_x0
xsubckt_272_nand3_x0 1 0 151 487 488 490 nand3_x0
xsubckt_281_and2_x1 1 0 480 216 291 and2_x1
xsubckt_599_dff_x1 1 0 134 292 11 dff_x1
xsubckt_598_dff_x1 1 0 135 292 8 dff_x1
xsubckt_597_dff_x1 1 0 136 292 6 dff_x1
xsubckt_596_dff_x1 1 0 137 292 226 dff_x1
xsubckt_493_and21nor_x0 1 0 321 639 636 322 and21nor_x0
xsubckt_401_and2_x1 1 0 390 26 291 and2_x1
xsubckt_341_and2_x1 1 0 435 226 291 and2_x1
xsubckt_61_and2_x1 1 0 636 637 291 and2_x1
xsubckt_495_or21nand_x0 1 0 110 320 321 323 or21nand_x0
xsubckt_445_and21nor_x0 1 0 357 639 636 358 and21nor_x0
xsubckt_132_nexor2_x0 1 0 593 692 79 nexor2_x0
xsubckt_163_and3_x1 1 0 568 636 639 667 and3_x1
xsubckt_181_and21nor_x0 1 0 555 639 636 556 and21nor_x0
xsubckt_262_inv_x0 1 0 495 25 inv_x0
xsubckt_289_and21nor_x0 1 0 474 639 636 475 and21nor_x0
xsubckt_447_or21nand_x0 1 0 119 356 357 359 or21nand_x0
xsubckt_392_nand3_x0 1 0 129 397 398 400 nand3_x0
xsubckt_378_and21nor_x0 1 0 407 639 636 408 and21nor_x0
xsubckt_114_nexor2_x0 1 0 604 686 87 nexor2_x0
xsubckt_111_and2_x1 1 0 604 605 184 and2_x1
xsubckt_57_and2_x1 1 0 640 641 697 and2_x1
xsubckt_183_or21nand_x0 1 0 128 554 555 557 or21nand_x0
xsubckt_296_nand3_x0 1 0 146 469 470 472 nand3_x0
xsubckt_334_inv_x0 1 0 441 38 inv_x0
xsubckt_146_and2_x1 1 0 582 668 169 and2_x1
xsubckt_144_and4_x1 1 0 583 584 587 636 639 and4_x1
xsubckt_131_and3_x1 1 0 592 595 176 175 and3_x1
xsubckt_170_and3_x1 1 0 563 567 636 639 and3_x1
xsubckt_185_and2_x1 1 0 552 200 291 and2_x1
xsubckt_230_and3_x1 1 0 518 522 636 639 and3_x1
xsubckt_245_and2_x1 1 0 507 210 291 and2_x1
xsubckt_305_and2_x1 1 0 462 220 291 and2_x1
xsubckt_321_nexor2_x0 1 0 37 209 450 nexor2_x0
xsubckt_153_nexor2_x0 1 0 6 195 576 nexor2_x0
xsubckt_406_inv_x0 1 0 387 51 inv_x0
xsubckt_151_and4_x1 1 0 577 578 579 636 639 and4_x1
xsubckt_192_and2_x1 1 0 547 201 291 and2_x1
xsubckt_252_and2_x1 1 0 502 211 291 and2_x1
xsubckt_294_or21nand_x0 1 0 470 640 635 471 or21nand_x0
xsubckt_298_inv_x0 1 0 468 32 inv_x0
xsubckt_312_and2_x1 1 0 457 221 291 and2_x1
xsubckt_485_and2_x1 1 0 327 57 291 and2_x1
xsubckt_148_nand3_x0 1 0 580 581 590 600 nand3_x0
xsubckt_117_nexor2_x0 1 0 602 180 84 nexor2_x0
xsubckt_246_or21nand_x0 1 0 506 640 635 507 or21nand_x0
xsubckt_530_and3_x1 1 0 293 297 636 639 and3_x1
xsubckt_481_and21nor_x0 1 0 330 639 636 331 and21nor_x0
xsubckt_470_and3_x1 1 0 338 342 636 639 and3_x1
xsubckt_333_nexor2_x0 1 0 39 210 441 nexor2_x0
xsubckt_43_nor4_x0 1 0 654 192 191 190 189 nor4_x0
xsubckt_62_nand2_x0 1 0 635 637 291 nand2_x0
xsubckt_165_nexor2_x0 1 0 8 196 567 nexor2_x0
xsubckt_209_and2_x1 1 0 534 204 291 and2_x1
xsubckt_501_nexor2_x0 1 0 31 224 315 nexor2_x0
xsubckt_492_and2_x1 1 0 322 59 291 and2_x1
xsubckt_483_or21nand_x0 1 0 112 329 330 332 or21nand_x0
xsubckt_433_and21nor_x0 1 0 366 639 636 367 and21nor_x0
xsubckt_430_inv_x0 1 0 369 56 inv_x0
xsubckt_381_nexor2_x0 1 0 48 214 405 nexor2_x0
xsubckt_156_and2_x1 1 0 574 195 291 and2_x1
xsubckt_277_and21nor_x0 1 0 483 639 636 484 and21nor_x0
xsubckt_435_or21nand_x0 1 0 121 365 366 368 or21nand_x0
xsubckt_427_and3_x1 1 0 370 636 639 658 and3_x1
xsubckt_102_and3_x1 1 0 611 612 615 643 and3_x1
xsubckt_87_and3_x1 1 0 620 622 627 192 and3_x1
xsubckt_50_nor4_x0 1 0 647 179 178 177 176 nor4_x0
xsubckt_71_nexor2_x0 1 0 631 669 75 nexor2_x0
xsubckt_74_and2_x1 1 0 628 168 167 and2_x1
xsubckt_171_or21nand_x0 1 0 150 563 564 566 or21nand_x0
xsubckt_216_and2_x1 1 0 529 205 291 and2_x1
xsubckt_229_and21nor_x0 1 0 519 639 636 520 and21nor_x0
xsubckt_279_or21nand_x0 1 0 149 482 483 485 or21nand_x0
xsubckt_502_inv_x0 1 0 315 20 inv_x0
xsubckt_449_and2_x1 1 0 354 44 291 and2_x1
xsubckt_400_nand2_x0 1 0 391 275 668 nand2_x0
xsubckt_394_inv_x0 1 0 396 49 inv_x0
xsubckt_389_and2_x1 1 0 399 22 291 and2_x1
xsubckt_374_and3_x1 1 0 410 414 636 639 and3_x1
xsubckt_345_nexor2_x0 1 0 41 211 432 nexor2_x0
xsubckt_137_and3_x1 1 0 588 589 636 639 and3_x1
xsubckt_46_nor4_x0 1 0 651 166 165 164 163 nor4_x0
xsubckt_48_nor2_x0 1 0 649 170 169 nor2_x0
xsubckt_177_nexor2_x0 1 0 11 197 558 nexor2_x0
xsubckt_210_and21nor_x0 1 0 533 639 636 534 and21nor_x0
xsubckt_318_and21nor_x0 1 0 452 639 636 453 and21nor_x0
.ends expmob2
