* Coriolis Structural SPICE Driver
* Generated on Apr 15, 2025, 14:55
* Cell/Subckt "expmob2".
*
* INTERF vss
* INTERF vdd
* INTERF outputs[99]
* INTERF outputs[98]
* INTERF outputs[97]
* INTERF outputs[96]
* INTERF outputs[95]
* INTERF outputs[94]
* INTERF outputs[93]
* INTERF outputs[92]
* INTERF outputs[91]
* INTERF outputs[90]
* INTERF outputs[9]
* INTERF outputs[89]
* INTERF outputs[88]
* INTERF outputs[87]
* INTERF outputs[86]
* INTERF outputs[85]
* INTERF outputs[84]
* INTERF outputs[83]
* INTERF outputs[82]
* INTERF outputs[81]
* INTERF outputs[80]
* INTERF outputs[8]
* INTERF outputs[79]
* INTERF outputs[78]
* INTERF outputs[77]
* INTERF outputs[76]
* INTERF outputs[75]
* INTERF outputs[74]
* INTERF outputs[73]
* INTERF outputs[72]
* INTERF outputs[71]
* INTERF outputs[70]
* INTERF outputs[7]
* INTERF outputs[69]
* INTERF outputs[68]
* INTERF outputs[67]
* INTERF outputs[66]
* INTERF outputs[65]
* INTERF outputs[64]
* INTERF outputs[63]
* INTERF outputs[62]
* INTERF outputs[61]
* INTERF outputs[60]
* INTERF outputs[6]
* INTERF outputs[59]
* INTERF outputs[58]
* INTERF outputs[57]
* INTERF outputs[56]
* INTERF outputs[55]
* INTERF outputs[54]
* INTERF outputs[53]
* INTERF outputs[52]
* INTERF outputs[51]
* INTERF outputs[50]
* INTERF outputs[5]
* INTERF outputs[49]
* INTERF outputs[48]
* INTERF outputs[47]
* INTERF outputs[46]
* INTERF outputs[45]
* INTERF outputs[44]
* INTERF outputs[43]
* INTERF outputs[42]
* INTERF outputs[41]
* INTERF outputs[40]
* INTERF outputs[4]
* INTERF outputs[39]
* INTERF outputs[38]
* INTERF outputs[37]
* INTERF outputs[36]
* INTERF outputs[35]
* INTERF outputs[34]
* INTERF outputs[33]
* INTERF outputs[32]
* INTERF outputs[31]
* INTERF outputs[30]
* INTERF outputs[3]
* INTERF outputs[29]
* INTERF outputs[28]
* INTERF outputs[27]
* INTERF outputs[26]
* INTERF outputs[255]
* INTERF outputs[254]
* INTERF outputs[253]
* INTERF outputs[252]
* INTERF outputs[251]
* INTERF outputs[250]
* INTERF outputs[25]
* INTERF outputs[249]
* INTERF outputs[248]
* INTERF outputs[247]
* INTERF outputs[246]
* INTERF outputs[245]
* INTERF outputs[244]
* INTERF outputs[243]
* INTERF outputs[242]
* INTERF outputs[241]
* INTERF outputs[240]
* INTERF outputs[24]
* INTERF outputs[239]
* INTERF outputs[238]
* INTERF outputs[237]
* INTERF outputs[236]
* INTERF outputs[235]
* INTERF outputs[234]
* INTERF outputs[233]
* INTERF outputs[232]
* INTERF outputs[231]
* INTERF outputs[230]
* INTERF outputs[23]
* INTERF outputs[229]
* INTERF outputs[228]
* INTERF outputs[227]
* INTERF outputs[226]
* INTERF outputs[225]
* INTERF outputs[224]
* INTERF outputs[223]
* INTERF outputs[222]
* INTERF outputs[221]
* INTERF outputs[220]
* INTERF outputs[22]
* INTERF outputs[219]
* INTERF outputs[218]
* INTERF outputs[217]
* INTERF outputs[216]
* INTERF outputs[215]
* INTERF outputs[214]
* INTERF outputs[213]
* INTERF outputs[212]
* INTERF outputs[211]
* INTERF outputs[210]
* INTERF outputs[21]
* INTERF outputs[209]
* INTERF outputs[208]
* INTERF outputs[207]
* INTERF outputs[206]
* INTERF outputs[205]
* INTERF outputs[204]
* INTERF outputs[203]
* INTERF outputs[202]
* INTERF outputs[201]
* INTERF outputs[200]
* INTERF outputs[20]
* INTERF outputs[2]
* INTERF outputs[199]
* INTERF outputs[198]
* INTERF outputs[197]
* INTERF outputs[196]
* INTERF outputs[195]
* INTERF outputs[194]
* INTERF outputs[193]
* INTERF outputs[192]
* INTERF outputs[191]
* INTERF outputs[190]
* INTERF outputs[19]
* INTERF outputs[189]
* INTERF outputs[188]
* INTERF outputs[187]
* INTERF outputs[186]
* INTERF outputs[185]
* INTERF outputs[184]
* INTERF outputs[183]
* INTERF outputs[182]
* INTERF outputs[181]
* INTERF outputs[180]
* INTERF outputs[18]
* INTERF outputs[179]
* INTERF outputs[178]
* INTERF outputs[177]
* INTERF outputs[176]
* INTERF outputs[175]
* INTERF outputs[174]
* INTERF outputs[173]
* INTERF outputs[172]
* INTERF outputs[171]
* INTERF outputs[170]
* INTERF outputs[17]
* INTERF outputs[169]
* INTERF outputs[168]
* INTERF outputs[167]
* INTERF outputs[166]
* INTERF outputs[165]
* INTERF outputs[164]
* INTERF outputs[163]
* INTERF outputs[162]
* INTERF outputs[161]
* INTERF outputs[160]
* INTERF outputs[16]
* INTERF outputs[159]
* INTERF outputs[158]
* INTERF outputs[157]
* INTERF outputs[156]
* INTERF outputs[155]
* INTERF outputs[154]
* INTERF outputs[153]
* INTERF outputs[152]
* INTERF outputs[151]
* INTERF outputs[150]
* INTERF outputs[15]
* INTERF outputs[149]
* INTERF outputs[148]
* INTERF outputs[147]
* INTERF outputs[146]
* INTERF outputs[145]
* INTERF outputs[144]
* INTERF outputs[143]
* INTERF outputs[142]
* INTERF outputs[141]
* INTERF outputs[140]
* INTERF outputs[14]
* INTERF outputs[139]
* INTERF outputs[138]
* INTERF outputs[137]
* INTERF outputs[136]
* INTERF outputs[135]
* INTERF outputs[134]
* INTERF outputs[133]
* INTERF outputs[132]
* INTERF outputs[131]
* INTERF outputs[130]
* INTERF outputs[13]
* INTERF outputs[129]
* INTERF outputs[128]
* INTERF outputs[127]
* INTERF outputs[126]
* INTERF outputs[125]
* INTERF outputs[124]
* INTERF outputs[123]
* INTERF outputs[122]
* INTERF outputs[121]
* INTERF outputs[120]
* INTERF outputs[12]
* INTERF outputs[119]
* INTERF outputs[118]
* INTERF outputs[117]
* INTERF outputs[116]
* INTERF outputs[115]
* INTERF outputs[114]
* INTERF outputs[113]
* INTERF outputs[112]
* INTERF outputs[111]
* INTERF outputs[110]
* INTERF outputs[11]
* INTERF outputs[109]
* INTERF outputs[108]
* INTERF outputs[107]
* INTERF outputs[106]
* INTERF outputs[105]
* INTERF outputs[104]
* INTERF outputs[103]
* INTERF outputs[102]
* INTERF outputs[101]
* INTERF outputs[100]
* INTERF outputs[10]
* INTERF outputs[1]
* INTERF outputs[0]
* INTERF inputs[99]
* INTERF inputs[98]
* INTERF inputs[97]
* INTERF inputs[96]
* INTERF inputs[95]
* INTERF inputs[94]
* INTERF inputs[93]
* INTERF inputs[92]
* INTERF inputs[91]
* INTERF inputs[90]
* INTERF inputs[9]
* INTERF inputs[89]
* INTERF inputs[88]
* INTERF inputs[87]
* INTERF inputs[86]
* INTERF inputs[85]
* INTERF inputs[84]
* INTERF inputs[83]
* INTERF inputs[82]
* INTERF inputs[81]
* INTERF inputs[80]
* INTERF inputs[8]
* INTERF inputs[79]
* INTERF inputs[78]
* INTERF inputs[77]
* INTERF inputs[76]
* INTERF inputs[75]
* INTERF inputs[74]
* INTERF inputs[73]
* INTERF inputs[72]
* INTERF inputs[71]
* INTERF inputs[70]
* INTERF inputs[7]
* INTERF inputs[69]
* INTERF inputs[68]
* INTERF inputs[67]
* INTERF inputs[66]
* INTERF inputs[65]
* INTERF inputs[64]
* INTERF inputs[63]
* INTERF inputs[62]
* INTERF inputs[61]
* INTERF inputs[60]
* INTERF inputs[6]
* INTERF inputs[59]
* INTERF inputs[58]
* INTERF inputs[57]
* INTERF inputs[56]
* INTERF inputs[55]
* INTERF inputs[54]
* INTERF inputs[53]
* INTERF inputs[52]
* INTERF inputs[51]
* INTERF inputs[50]
* INTERF inputs[5]
* INTERF inputs[49]
* INTERF inputs[48]
* INTERF inputs[47]
* INTERF inputs[46]
* INTERF inputs[45]
* INTERF inputs[44]
* INTERF inputs[43]
* INTERF inputs[42]
* INTERF inputs[41]
* INTERF inputs[40]
* INTERF inputs[4]
* INTERF inputs[39]
* INTERF inputs[38]
* INTERF inputs[37]
* INTERF inputs[36]
* INTERF inputs[35]
* INTERF inputs[34]
* INTERF inputs[33]
* INTERF inputs[32]
* INTERF inputs[31]
* INTERF inputs[30]
* INTERF inputs[3]
* INTERF inputs[29]
* INTERF inputs[28]
* INTERF inputs[27]
* INTERF inputs[26]
* INTERF inputs[255]
* INTERF inputs[254]
* INTERF inputs[253]
* INTERF inputs[252]
* INTERF inputs[251]
* INTERF inputs[250]
* INTERF inputs[25]
* INTERF inputs[249]
* INTERF inputs[248]
* INTERF inputs[247]
* INTERF inputs[246]
* INTERF inputs[245]
* INTERF inputs[244]
* INTERF inputs[243]
* INTERF inputs[242]
* INTERF inputs[241]
* INTERF inputs[240]
* INTERF inputs[24]
* INTERF inputs[239]
* INTERF inputs[238]
* INTERF inputs[237]
* INTERF inputs[236]
* INTERF inputs[235]
* INTERF inputs[234]
* INTERF inputs[233]
* INTERF inputs[232]
* INTERF inputs[231]
* INTERF inputs[230]
* INTERF inputs[23]
* INTERF inputs[229]
* INTERF inputs[228]
* INTERF inputs[227]
* INTERF inputs[226]
* INTERF inputs[225]
* INTERF inputs[224]
* INTERF inputs[223]
* INTERF inputs[222]
* INTERF inputs[221]
* INTERF inputs[220]
* INTERF inputs[22]
* INTERF inputs[219]
* INTERF inputs[218]
* INTERF inputs[217]
* INTERF inputs[216]
* INTERF inputs[215]
* INTERF inputs[214]
* INTERF inputs[213]
* INTERF inputs[212]
* INTERF inputs[211]
* INTERF inputs[210]
* INTERF inputs[21]
* INTERF inputs[209]
* INTERF inputs[208]
* INTERF inputs[207]
* INTERF inputs[206]
* INTERF inputs[205]
* INTERF inputs[204]
* INTERF inputs[203]
* INTERF inputs[202]
* INTERF inputs[201]
* INTERF inputs[200]
* INTERF inputs[20]
* INTERF inputs[2]
* INTERF inputs[199]
* INTERF inputs[198]
* INTERF inputs[197]
* INTERF inputs[196]
* INTERF inputs[195]
* INTERF inputs[194]
* INTERF inputs[193]
* INTERF inputs[192]
* INTERF inputs[191]
* INTERF inputs[190]
* INTERF inputs[19]
* INTERF inputs[189]
* INTERF inputs[188]
* INTERF inputs[187]
* INTERF inputs[186]
* INTERF inputs[185]
* INTERF inputs[184]
* INTERF inputs[183]
* INTERF inputs[182]
* INTERF inputs[181]
* INTERF inputs[180]
* INTERF inputs[18]
* INTERF inputs[179]
* INTERF inputs[178]
* INTERF inputs[177]
* INTERF inputs[176]
* INTERF inputs[175]
* INTERF inputs[174]
* INTERF inputs[173]
* INTERF inputs[172]
* INTERF inputs[171]
* INTERF inputs[170]
* INTERF inputs[17]
* INTERF inputs[169]
* INTERF inputs[168]
* INTERF inputs[167]
* INTERF inputs[166]
* INTERF inputs[165]
* INTERF inputs[164]
* INTERF inputs[163]
* INTERF inputs[162]
* INTERF inputs[161]
* INTERF inputs[160]
* INTERF inputs[16]
* INTERF inputs[159]
* INTERF inputs[158]
* INTERF inputs[157]
* INTERF inputs[156]
* INTERF inputs[155]
* INTERF inputs[154]
* INTERF inputs[153]
* INTERF inputs[152]
* INTERF inputs[151]
* INTERF inputs[150]
* INTERF inputs[15]
* INTERF inputs[149]
* INTERF inputs[148]
* INTERF inputs[147]
* INTERF inputs[146]
* INTERF inputs[145]
* INTERF inputs[144]
* INTERF inputs[143]
* INTERF inputs[142]
* INTERF inputs[141]
* INTERF inputs[140]
* INTERF inputs[14]
* INTERF inputs[139]
* INTERF inputs[138]
* INTERF inputs[137]
* INTERF inputs[136]
* INTERF inputs[135]
* INTERF inputs[134]
* INTERF inputs[133]
* INTERF inputs[132]
* INTERF inputs[131]
* INTERF inputs[130]
* INTERF inputs[13]
* INTERF inputs[129]
* INTERF inputs[128]
* INTERF inputs[127]
* INTERF inputs[126]
* INTERF inputs[125]
* INTERF inputs[124]
* INTERF inputs[123]
* INTERF inputs[122]
* INTERF inputs[121]
* INTERF inputs[120]
* INTERF inputs[12]
* INTERF inputs[119]
* INTERF inputs[118]
* INTERF inputs[117]
* INTERF inputs[116]
* INTERF inputs[115]
* INTERF inputs[114]
* INTERF inputs[113]
* INTERF inputs[112]
* INTERF inputs[111]
* INTERF inputs[110]
* INTERF inputs[11]
* INTERF inputs[109]
* INTERF inputs[108]
* INTERF inputs[107]
* INTERF inputs[106]
* INTERF inputs[105]
* INTERF inputs[104]
* INTERF inputs[103]
* INTERF inputs[102]
* INTERF inputs[101]
* INTERF inputs[100]
* INTERF inputs[10]
* INTERF inputs[1]
* INTERF inputs[0]
* INTERF clk

* Terminal models (aka standard cells) used througout all the hierarchy.
.include dff_x1.spi
.include xor2_x0.spi
.include and4_x1.spi
.include nand2_x0.spi
.include and2_x1.spi
.include and21nor_x0.spi
.include nand4_x0.spi
.include nor2_x0.spi
.include inv_x0.spi
.include nexor2_x0.spi
.include nand3_x0.spi
.include and3_x1.spi
.include mux2_x1.spi
.include nor4_x0.spi
.include one_x1.spi

* Non-terminal models (part of the user's design hierarchy).

.subckt expmob2 0 1 2 3 4 5 6 7 8 9 10 11 12 13 14 15 16 17 18 19 20 21 22 23 24 25 26 27 28 29 30 31 32 33 34 35 36 37 38 39 40 41 42 43 44 45 46 47 48 49 50 51 52 53 54 55 56 57 58 59 60 61 62 63 64 65 66 67 68 69 70 71 72 73 74 75 76 77 78 79 80 81 82 83 84 85 86 87 88 89 90 91 92 93 94 95 96 97 98 99 100 101 102 103 104 105 106 107 108 109 110 111 112 113 114 115 116 117 118 119 120 121 122 123 124 125 126 127 128 129 130 131 132 133 134 135 136 137 138 139 140 141 142 143 144 145 146 147 148 149 150 151 152 153 154 155 156 157 158 159 160 161 162 163 164 165 166 167 168 169 170 171 172 173 174 175 176 177 178 179 180 181 182 183 184 185 186 187 188 189 190 191 192 193 194 195 196 197 198 199 200 201 202 203 204 205 206 207 208 209 210 211 212 213 214 215 216 217 218 219 220 221 222 223 224 225 226 227 228 229 230 231 232 233 234 235 236 237 238 239 240 241 242 243 244 245 246 247 248 249 250 251 252 253 254 255 256 257 419 420 421 422 423 424 425 426 427 428 429 430 431 432 433 434 435 436 437 438 439 440 441 442 443 444 445 446 447 448 449 450 451 452 453 454 455 456 457 458 459 460 461 462 463 464 465 466 467 468 469 470 471 472 473 474 475 476 477 478 479 480 481 482 483 484 485 486 487 488 489 490 491 492 493 494 495 496 497 498 499 500 501 502 503 504 505 506 507 508 509 510 511 512 513 514 515 516 517 518 519 520 521 522 523 524 525 526 527 528 529 530 531 532 533 534 535 536 537 538 539 540 541 542 543 544 545 546 547 548 549 550 551 552 553 554 555 556 557 558 559 560 561 562 563 564 565 566 567 568 569 570 571 572 573 574 575 576 577 578 579 580 581 582 583 584 585 586 587 588 589 590 591 592 593 594 595 596 597 598 599 600 601 602 603 604 605 606 607 608 609 610 611 612 613 614 615 616 617 618 619 620 621 622 623 624 625 626 627 628 629 630 631 632 633 634 635 636 637 638 639 640 641 642 643 644 645 646 647 648 649 650 651 652 653 654 655 656 657 658 659 660 661 662 663 664 665 666 667 668 669 670 671 672 673 674 676
* NET     0 = vss
* NET     1 = vdd
* NET     2 = outputs[99]
* NET     3 = outputs[98]
* NET     4 = outputs[97]
* NET     5 = outputs[96]
* NET     6 = outputs[95]
* NET     7 = outputs[94]
* NET     8 = outputs[93]
* NET     9 = outputs[92]
* NET    10 = outputs[91]
* NET    11 = outputs[90]
* NET    12 = outputs[9]
* NET    13 = outputs[89]
* NET    14 = outputs[88]
* NET    15 = outputs[87]
* NET    16 = outputs[86]
* NET    17 = outputs[85]
* NET    18 = outputs[84]
* NET    19 = outputs[83]
* NET    20 = outputs[82]
* NET    21 = outputs[81]
* NET    22 = outputs[80]
* NET    23 = outputs[8]
* NET    24 = outputs[79]
* NET    25 = outputs[78]
* NET    26 = outputs[77]
* NET    27 = outputs[76]
* NET    28 = outputs[75]
* NET    29 = outputs[74]
* NET    30 = outputs[73]
* NET    31 = outputs[72]
* NET    32 = outputs[71]
* NET    33 = outputs[70]
* NET    34 = outputs[7]
* NET    35 = outputs[69]
* NET    36 = outputs[68]
* NET    37 = outputs[67]
* NET    38 = outputs[66]
* NET    39 = outputs[65]
* NET    40 = outputs[64]
* NET    41 = outputs[63]
* NET    42 = outputs[62]
* NET    43 = outputs[61]
* NET    44 = outputs[60]
* NET    45 = outputs[6]
* NET    46 = outputs[59]
* NET    47 = outputs[58]
* NET    48 = outputs[57]
* NET    49 = outputs[56]
* NET    50 = outputs[55]
* NET    51 = outputs[54]
* NET    52 = outputs[53]
* NET    53 = outputs[52]
* NET    54 = outputs[51]
* NET    55 = outputs[50]
* NET    56 = outputs[5]
* NET    57 = outputs[49]
* NET    58 = outputs[48]
* NET    59 = outputs[47]
* NET    60 = outputs[46]
* NET    61 = outputs[45]
* NET    62 = outputs[44]
* NET    63 = outputs[43]
* NET    64 = outputs[42]
* NET    65 = outputs[41]
* NET    66 = outputs[40]
* NET    67 = outputs[4]
* NET    68 = outputs[39]
* NET    69 = outputs[38]
* NET    70 = outputs[37]
* NET    71 = outputs[36]
* NET    72 = outputs[35]
* NET    73 = outputs[34]
* NET    74 = outputs[33]
* NET    75 = outputs[32]
* NET    76 = outputs[31]
* NET    77 = outputs[30]
* NET    78 = outputs[3]
* NET    79 = outputs[29]
* NET    80 = outputs[28]
* NET    81 = outputs[27]
* NET    82 = outputs[26]
* NET    83 = outputs[255]
* NET    84 = outputs[254]
* NET    85 = outputs[253]
* NET    86 = outputs[252]
* NET    87 = outputs[251]
* NET    88 = outputs[250]
* NET    89 = outputs[25]
* NET    90 = outputs[249]
* NET    91 = outputs[248]
* NET    92 = outputs[247]
* NET    93 = outputs[246]
* NET    94 = outputs[245]
* NET    95 = outputs[244]
* NET    96 = outputs[243]
* NET    97 = outputs[242]
* NET    98 = outputs[241]
* NET    99 = outputs[240]
* NET   100 = outputs[24]
* NET   101 = outputs[239]
* NET   102 = outputs[238]
* NET   103 = outputs[237]
* NET   104 = outputs[236]
* NET   105 = outputs[235]
* NET   106 = outputs[234]
* NET   107 = outputs[233]
* NET   108 = outputs[232]
* NET   109 = outputs[231]
* NET   110 = outputs[230]
* NET   111 = outputs[23]
* NET   112 = outputs[229]
* NET   113 = outputs[228]
* NET   114 = outputs[227]
* NET   115 = outputs[226]
* NET   116 = outputs[225]
* NET   117 = outputs[224]
* NET   118 = outputs[223]
* NET   119 = outputs[222]
* NET   120 = outputs[221]
* NET   121 = outputs[220]
* NET   122 = outputs[22]
* NET   123 = outputs[219]
* NET   124 = outputs[218]
* NET   125 = outputs[217]
* NET   126 = outputs[216]
* NET   127 = outputs[215]
* NET   128 = outputs[214]
* NET   129 = outputs[213]
* NET   130 = outputs[212]
* NET   131 = outputs[211]
* NET   132 = outputs[210]
* NET   133 = outputs[21]
* NET   134 = outputs[209]
* NET   135 = outputs[208]
* NET   136 = outputs[207]
* NET   137 = outputs[206]
* NET   138 = outputs[205]
* NET   139 = outputs[204]
* NET   140 = outputs[203]
* NET   141 = outputs[202]
* NET   142 = outputs[201]
* NET   143 = outputs[200]
* NET   144 = outputs[20]
* NET   145 = outputs[2]
* NET   146 = outputs[199]
* NET   147 = outputs[198]
* NET   148 = outputs[197]
* NET   149 = outputs[196]
* NET   150 = outputs[195]
* NET   151 = outputs[194]
* NET   152 = outputs[193]
* NET   153 = outputs[192]
* NET   154 = outputs[191]
* NET   155 = outputs[190]
* NET   156 = outputs[19]
* NET   157 = outputs[189]
* NET   158 = outputs[188]
* NET   159 = outputs[187]
* NET   160 = outputs[186]
* NET   161 = outputs[185]
* NET   162 = outputs[184]
* NET   163 = outputs[183]
* NET   164 = outputs[182]
* NET   165 = outputs[181]
* NET   166 = outputs[180]
* NET   167 = outputs[18]
* NET   168 = outputs[179]
* NET   169 = outputs[178]
* NET   170 = outputs[177]
* NET   171 = outputs[176]
* NET   172 = outputs[175]
* NET   173 = outputs[174]
* NET   174 = outputs[173]
* NET   175 = outputs[172]
* NET   176 = outputs[171]
* NET   177 = outputs[170]
* NET   178 = outputs[17]
* NET   179 = outputs[169]
* NET   180 = outputs[168]
* NET   181 = outputs[167]
* NET   182 = outputs[166]
* NET   183 = outputs[165]
* NET   184 = outputs[164]
* NET   185 = outputs[163]
* NET   186 = outputs[162]
* NET   187 = outputs[161]
* NET   188 = outputs[160]
* NET   189 = outputs[16]
* NET   190 = outputs[159]
* NET   191 = outputs[158]
* NET   192 = outputs[157]
* NET   193 = outputs[156]
* NET   194 = outputs[155]
* NET   195 = outputs[154]
* NET   196 = outputs[153]
* NET   197 = outputs[152]
* NET   198 = outputs[151]
* NET   199 = outputs[150]
* NET   200 = outputs[15]
* NET   201 = outputs[149]
* NET   202 = outputs[148]
* NET   203 = outputs[147]
* NET   204 = outputs[146]
* NET   205 = outputs[145]
* NET   206 = outputs[144]
* NET   207 = outputs[143]
* NET   208 = outputs[142]
* NET   209 = outputs[141]
* NET   210 = outputs[140]
* NET   211 = outputs[14]
* NET   212 = outputs[139]
* NET   213 = outputs[138]
* NET   214 = outputs[137]
* NET   215 = outputs[136]
* NET   216 = outputs[135]
* NET   217 = outputs[134]
* NET   218 = outputs[133]
* NET   219 = outputs[132]
* NET   220 = outputs[131]
* NET   221 = outputs[130]
* NET   222 = outputs[13]
* NET   223 = outputs[129]
* NET   224 = outputs[128]
* NET   225 = outputs[127]
* NET   226 = outputs[126]
* NET   227 = outputs[125]
* NET   228 = outputs[124]
* NET   229 = outputs[123]
* NET   230 = outputs[122]
* NET   231 = outputs[121]
* NET   232 = outputs[120]
* NET   233 = outputs[12]
* NET   234 = outputs[119]
* NET   235 = outputs[118]
* NET   236 = outputs[117]
* NET   237 = outputs[116]
* NET   238 = outputs[115]
* NET   239 = outputs[114]
* NET   240 = outputs[113]
* NET   241 = outputs[112]
* NET   242 = outputs[111]
* NET   243 = outputs[110]
* NET   244 = outputs[11]
* NET   245 = outputs[109]
* NET   246 = outputs[108]
* NET   247 = outputs[107]
* NET   248 = outputs[106]
* NET   249 = outputs[105]
* NET   250 = outputs[104]
* NET   251 = outputs[103]
* NET   252 = outputs[102]
* NET   253 = outputs[101]
* NET   254 = outputs[100]
* NET   255 = outputs[10]
* NET   256 = outputs[1]
* NET   257 = outputs[0]
* NET   258 = one_0
* NET   259 = n[9]
* NET   260 = n[8]
* NET   261 = n[7]
* NET   262 = n[6]
* NET   263 = n[5]
* NET   264 = n[4]
* NET   265 = n[31]
* NET   266 = n[30]
* NET   267 = n[3]
* NET   268 = n[29]
* NET   269 = n[28]
* NET   270 = n[27]
* NET   271 = n[26]
* NET   272 = n[25]
* NET   273 = n[24]
* NET   274 = n[23]
* NET   275 = n[22]
* NET   276 = n[21]
* NET   277 = n[20]
* NET   278 = n[2]
* NET   279 = n[19]
* NET   280 = n[18]
* NET   281 = n[17]
* NET   282 = n[16]
* NET   283 = n[15]
* NET   284 = n[14]
* NET   285 = n[13]
* NET   286 = n[12]
* NET   287 = n[11]
* NET   288 = n[10]
* NET   289 = n[1]
* NET   290 = n[0]
* NET   291 = mem_inputs[255]
* NET   292 = mem_inputs[254]
* NET   293 = mem_inputs[253]
* NET   294 = mem_inputs[252]
* NET   295 = mem_inputs[251]
* NET   296 = mem_inputs[250]
* NET   297 = mem_inputs[249]
* NET   298 = mem_inputs[248]
* NET   299 = mem_inputs[247]
* NET   300 = mem_inputs[246]
* NET   301 = mem_inputs[245]
* NET   302 = mem_inputs[244]
* NET   303 = mem_inputs[243]
* NET   304 = mem_inputs[242]
* NET   305 = mem_inputs[241]
* NET   306 = mem_inputs[240]
* NET   307 = mem_inputs[239]
* NET   308 = mem_inputs[238]
* NET   309 = mem_inputs[237]
* NET   310 = mem_inputs[236]
* NET   311 = mem_inputs[235]
* NET   312 = mem_inputs[234]
* NET   313 = mem_inputs[233]
* NET   314 = mem_inputs[232]
* NET   315 = mem_inputs[231]
* NET   316 = mem_inputs[230]
* NET   317 = mem_inputs[229]
* NET   318 = mem_inputs[228]
* NET   319 = mem_inputs[227]
* NET   320 = mem_inputs[226]
* NET   321 = mem_inputs[225]
* NET   322 = mem_inputs[224]
* NET   323 = mem_inputs[223]
* NET   324 = mem_inputs[222]
* NET   325 = mem_inputs[221]
* NET   326 = mem_inputs[220]
* NET   327 = mem_inputs[219]
* NET   328 = mem_inputs[218]
* NET   329 = mem_inputs[217]
* NET   330 = mem_inputs[216]
* NET   331 = mem_inputs[215]
* NET   332 = mem_inputs[214]
* NET   333 = mem_inputs[213]
* NET   334 = mem_inputs[212]
* NET   335 = mem_inputs[211]
* NET   336 = mem_inputs[210]
* NET   337 = mem_inputs[209]
* NET   338 = mem_inputs[208]
* NET   339 = mem_inputs[207]
* NET   340 = mem_inputs[206]
* NET   341 = mem_inputs[205]
* NET   342 = mem_inputs[204]
* NET   343 = mem_inputs[203]
* NET   344 = mem_inputs[202]
* NET   345 = mem_inputs[201]
* NET   346 = mem_inputs[200]
* NET   347 = mem_inputs[199]
* NET   348 = mem_inputs[198]
* NET   349 = mem_inputs[197]
* NET   350 = mem_inputs[196]
* NET   351 = mem_inputs[195]
* NET   352 = mem_inputs[194]
* NET   353 = mem_inputs[193]
* NET   354 = mem_inputs[192]
* NET   355 = mem_inputs[191]
* NET   356 = mem_inputs[190]
* NET   357 = mem_inputs[189]
* NET   358 = mem_inputs[188]
* NET   359 = mem_inputs[187]
* NET   360 = mem_inputs[186]
* NET   361 = mem_inputs[185]
* NET   362 = mem_inputs[184]
* NET   363 = mem_inputs[183]
* NET   364 = mem_inputs[182]
* NET   365 = mem_inputs[181]
* NET   366 = mem_inputs[180]
* NET   367 = mem_inputs[179]
* NET   368 = mem_inputs[178]
* NET   369 = mem_inputs[177]
* NET   370 = mem_inputs[176]
* NET   371 = mem_inputs[175]
* NET   372 = mem_inputs[174]
* NET   373 = mem_inputs[173]
* NET   374 = mem_inputs[172]
* NET   375 = mem_inputs[171]
* NET   376 = mem_inputs[170]
* NET   377 = mem_inputs[169]
* NET   378 = mem_inputs[168]
* NET   379 = mem_inputs[167]
* NET   380 = mem_inputs[166]
* NET   381 = mem_inputs[165]
* NET   382 = mem_inputs[164]
* NET   383 = mem_inputs[163]
* NET   384 = mem_inputs[162]
* NET   385 = mem_inputs[161]
* NET   386 = mem_inputs[160]
* NET   387 = mem_inputs[159]
* NET   388 = mem_inputs[158]
* NET   389 = mem_inputs[157]
* NET   390 = mem_inputs[156]
* NET   391 = mem_inputs[155]
* NET   392 = mem_inputs[154]
* NET   393 = mem_inputs[153]
* NET   394 = mem_inputs[152]
* NET   395 = mem_inputs[151]
* NET   396 = mem_inputs[150]
* NET   397 = mem_inputs[149]
* NET   398 = mem_inputs[148]
* NET   399 = mem_inputs[147]
* NET   400 = mem_inputs[146]
* NET   401 = mem_inputs[145]
* NET   402 = mem_inputs[144]
* NET   403 = mem_inputs[143]
* NET   404 = mem_inputs[142]
* NET   405 = mem_inputs[141]
* NET   406 = mem_inputs[140]
* NET   407 = mem_inputs[139]
* NET   408 = mem_inputs[138]
* NET   409 = mem_inputs[137]
* NET   410 = mem_inputs[136]
* NET   411 = mem_inputs[135]
* NET   412 = mem_inputs[134]
* NET   413 = mem_inputs[133]
* NET   414 = mem_inputs[132]
* NET   415 = mem_inputs[131]
* NET   416 = mem_inputs[130]
* NET   417 = mem_inputs[129]
* NET   418 = mem_inputs[128]
* NET   419 = inputs[99]
* NET   420 = inputs[98]
* NET   421 = inputs[97]
* NET   422 = inputs[96]
* NET   423 = inputs[95]
* NET   424 = inputs[94]
* NET   425 = inputs[93]
* NET   426 = inputs[92]
* NET   427 = inputs[91]
* NET   428 = inputs[90]
* NET   429 = inputs[9]
* NET   430 = inputs[89]
* NET   431 = inputs[88]
* NET   432 = inputs[87]
* NET   433 = inputs[86]
* NET   434 = inputs[85]
* NET   435 = inputs[84]
* NET   436 = inputs[83]
* NET   437 = inputs[82]
* NET   438 = inputs[81]
* NET   439 = inputs[80]
* NET   440 = inputs[8]
* NET   441 = inputs[79]
* NET   442 = inputs[78]
* NET   443 = inputs[77]
* NET   444 = inputs[76]
* NET   445 = inputs[75]
* NET   446 = inputs[74]
* NET   447 = inputs[73]
* NET   448 = inputs[72]
* NET   449 = inputs[71]
* NET   450 = inputs[70]
* NET   451 = inputs[7]
* NET   452 = inputs[69]
* NET   453 = inputs[68]
* NET   454 = inputs[67]
* NET   455 = inputs[66]
* NET   456 = inputs[65]
* NET   457 = inputs[64]
* NET   458 = inputs[63]
* NET   459 = inputs[62]
* NET   460 = inputs[61]
* NET   461 = inputs[60]
* NET   462 = inputs[6]
* NET   463 = inputs[59]
* NET   464 = inputs[58]
* NET   465 = inputs[57]
* NET   466 = inputs[56]
* NET   467 = inputs[55]
* NET   468 = inputs[54]
* NET   469 = inputs[53]
* NET   470 = inputs[52]
* NET   471 = inputs[51]
* NET   472 = inputs[50]
* NET   473 = inputs[5]
* NET   474 = inputs[49]
* NET   475 = inputs[48]
* NET   476 = inputs[47]
* NET   477 = inputs[46]
* NET   478 = inputs[45]
* NET   479 = inputs[44]
* NET   480 = inputs[43]
* NET   481 = inputs[42]
* NET   482 = inputs[41]
* NET   483 = inputs[40]
* NET   484 = inputs[4]
* NET   485 = inputs[39]
* NET   486 = inputs[38]
* NET   487 = inputs[37]
* NET   488 = inputs[36]
* NET   489 = inputs[35]
* NET   490 = inputs[34]
* NET   491 = inputs[33]
* NET   492 = inputs[32]
* NET   493 = inputs[31]
* NET   494 = inputs[30]
* NET   495 = inputs[3]
* NET   496 = inputs[29]
* NET   497 = inputs[28]
* NET   498 = inputs[27]
* NET   499 = inputs[26]
* NET   500 = inputs[255]
* NET   501 = inputs[254]
* NET   502 = inputs[253]
* NET   503 = inputs[252]
* NET   504 = inputs[251]
* NET   505 = inputs[250]
* NET   506 = inputs[25]
* NET   507 = inputs[249]
* NET   508 = inputs[248]
* NET   509 = inputs[247]
* NET   510 = inputs[246]
* NET   511 = inputs[245]
* NET   512 = inputs[244]
* NET   513 = inputs[243]
* NET   514 = inputs[242]
* NET   515 = inputs[241]
* NET   516 = inputs[240]
* NET   517 = inputs[24]
* NET   518 = inputs[239]
* NET   519 = inputs[238]
* NET   520 = inputs[237]
* NET   521 = inputs[236]
* NET   522 = inputs[235]
* NET   523 = inputs[234]
* NET   524 = inputs[233]
* NET   525 = inputs[232]
* NET   526 = inputs[231]
* NET   527 = inputs[230]
* NET   528 = inputs[23]
* NET   529 = inputs[229]
* NET   530 = inputs[228]
* NET   531 = inputs[227]
* NET   532 = inputs[226]
* NET   533 = inputs[225]
* NET   534 = inputs[224]
* NET   535 = inputs[223]
* NET   536 = inputs[222]
* NET   537 = inputs[221]
* NET   538 = inputs[220]
* NET   539 = inputs[22]
* NET   540 = inputs[219]
* NET   541 = inputs[218]
* NET   542 = inputs[217]
* NET   543 = inputs[216]
* NET   544 = inputs[215]
* NET   545 = inputs[214]
* NET   546 = inputs[213]
* NET   547 = inputs[212]
* NET   548 = inputs[211]
* NET   549 = inputs[210]
* NET   550 = inputs[21]
* NET   551 = inputs[209]
* NET   552 = inputs[208]
* NET   553 = inputs[207]
* NET   554 = inputs[206]
* NET   555 = inputs[205]
* NET   556 = inputs[204]
* NET   557 = inputs[203]
* NET   558 = inputs[202]
* NET   559 = inputs[201]
* NET   560 = inputs[200]
* NET   561 = inputs[20]
* NET   562 = inputs[2]
* NET   563 = inputs[199]
* NET   564 = inputs[198]
* NET   565 = inputs[197]
* NET   566 = inputs[196]
* NET   567 = inputs[195]
* NET   568 = inputs[194]
* NET   569 = inputs[193]
* NET   570 = inputs[192]
* NET   571 = inputs[191]
* NET   572 = inputs[190]
* NET   573 = inputs[19]
* NET   574 = inputs[189]
* NET   575 = inputs[188]
* NET   576 = inputs[187]
* NET   577 = inputs[186]
* NET   578 = inputs[185]
* NET   579 = inputs[184]
* NET   580 = inputs[183]
* NET   581 = inputs[182]
* NET   582 = inputs[181]
* NET   583 = inputs[180]
* NET   584 = inputs[18]
* NET   585 = inputs[179]
* NET   586 = inputs[178]
* NET   587 = inputs[177]
* NET   588 = inputs[176]
* NET   589 = inputs[175]
* NET   590 = inputs[174]
* NET   591 = inputs[173]
* NET   592 = inputs[172]
* NET   593 = inputs[171]
* NET   594 = inputs[170]
* NET   595 = inputs[17]
* NET   596 = inputs[169]
* NET   597 = inputs[168]
* NET   598 = inputs[167]
* NET   599 = inputs[166]
* NET   600 = inputs[165]
* NET   601 = inputs[164]
* NET   602 = inputs[163]
* NET   603 = inputs[162]
* NET   604 = inputs[161]
* NET   605 = inputs[160]
* NET   606 = inputs[16]
* NET   607 = inputs[159]
* NET   608 = inputs[158]
* NET   609 = inputs[157]
* NET   610 = inputs[156]
* NET   611 = inputs[155]
* NET   612 = inputs[154]
* NET   613 = inputs[153]
* NET   614 = inputs[152]
* NET   615 = inputs[151]
* NET   616 = inputs[150]
* NET   617 = inputs[15]
* NET   618 = inputs[149]
* NET   619 = inputs[148]
* NET   620 = inputs[147]
* NET   621 = inputs[146]
* NET   622 = inputs[145]
* NET   623 = inputs[144]
* NET   624 = inputs[143]
* NET   625 = inputs[142]
* NET   626 = inputs[141]
* NET   627 = inputs[140]
* NET   628 = inputs[14]
* NET   629 = inputs[139]
* NET   630 = inputs[138]
* NET   631 = inputs[137]
* NET   632 = inputs[136]
* NET   633 = inputs[135]
* NET   634 = inputs[134]
* NET   635 = inputs[133]
* NET   636 = inputs[132]
* NET   637 = inputs[131]
* NET   638 = inputs[130]
* NET   639 = inputs[13]
* NET   640 = inputs[129]
* NET   641 = inputs[128]
* NET   642 = inputs[127]
* NET   643 = inputs[126]
* NET   644 = inputs[125]
* NET   645 = inputs[124]
* NET   646 = inputs[123]
* NET   647 = inputs[122]
* NET   648 = inputs[121]
* NET   649 = inputs[120]
* NET   650 = inputs[12]
* NET   651 = inputs[119]
* NET   652 = inputs[118]
* NET   653 = inputs[117]
* NET   654 = inputs[116]
* NET   655 = inputs[115]
* NET   656 = inputs[114]
* NET   657 = inputs[113]
* NET   658 = inputs[112]
* NET   659 = inputs[111]
* NET   660 = inputs[110]
* NET   661 = inputs[11]
* NET   662 = inputs[109]
* NET   663 = inputs[108]
* NET   664 = inputs[107]
* NET   665 = inputs[106]
* NET   666 = inputs[105]
* NET   667 = inputs[104]
* NET   668 = inputs[103]
* NET   669 = inputs[102]
* NET   670 = inputs[101]
* NET   671 = inputs[100]
* NET   672 = inputs[10]
* NET   673 = inputs[1]
* NET   674 = inputs[0]
* NET   675 = init
* NET   676 = clk
* NET   677 = abc_2885_new_n989
* NET   678 = abc_2885_new_n988
* NET   679 = abc_2885_new_n987
* NET   680 = abc_2885_new_n986
* NET   681 = abc_2885_new_n985
* NET   682 = abc_2885_new_n984
* NET   683 = abc_2885_new_n983
* NET   684 = abc_2885_new_n982
* NET   685 = abc_2885_new_n981
* NET   686 = abc_2885_new_n980
* NET   687 = abc_2885_new_n979
* NET   688 = abc_2885_new_n978
* NET   689 = abc_2885_new_n977
* NET   690 = abc_2885_new_n976
* NET   691 = abc_2885_new_n975
* NET   692 = abc_2885_new_n974
* NET   693 = abc_2885_new_n973
* NET   694 = abc_2885_new_n972
* NET   695 = abc_2885_new_n971
* NET   696 = abc_2885_new_n970
* NET   697 = abc_2885_new_n969
* NET   698 = abc_2885_new_n968
* NET   699 = abc_2885_new_n967
* NET   700 = abc_2885_new_n966
* NET   701 = abc_2885_new_n965
* NET   702 = abc_2885_new_n964
* NET   703 = abc_2885_new_n963
* NET   704 = abc_2885_new_n962
* NET   705 = abc_2885_new_n2294
* NET   706 = abc_2885_new_n2292
* NET   707 = abc_2885_new_n2290
* NET   708 = abc_2885_new_n2288
* NET   709 = abc_2885_new_n2286
* NET   710 = abc_2885_new_n2284
* NET   711 = abc_2885_new_n2282
* NET   712 = abc_2885_new_n2280
* NET   713 = abc_2885_new_n2278
* NET   714 = abc_2885_new_n2276
* NET   715 = abc_2885_new_n2275
* NET   716 = abc_2885_new_n2273
* NET   717 = abc_2885_new_n2272
* NET   718 = abc_2885_new_n2271
* NET   719 = abc_2885_new_n2270
* NET   720 = abc_2885_new_n2269
* NET   721 = abc_2885_new_n2268
* NET   722 = abc_2885_new_n2265
* NET   723 = abc_2885_new_n2263
* NET   724 = abc_2885_new_n2262
* NET   725 = abc_2885_new_n2260
* NET   726 = abc_2885_new_n2258
* NET   727 = abc_2885_new_n2257
* NET   728 = abc_2885_new_n2256
* NET   729 = abc_2885_new_n2254
* NET   730 = abc_2885_new_n2252
* NET   731 = abc_2885_new_n2251
* NET   732 = abc_2885_new_n2249
* NET   733 = abc_2885_new_n2248
* NET   734 = abc_2885_new_n2247
* NET   735 = abc_2885_new_n2246
* NET   736 = abc_2885_new_n2243
* NET   737 = abc_2885_new_n2241
* NET   738 = abc_2885_new_n2239
* NET   739 = abc_2885_new_n2237
* NET   740 = abc_2885_new_n2236
* NET   741 = abc_2885_new_n2235
* NET   742 = abc_2885_new_n2233
* NET   743 = abc_2885_new_n2231
* NET   744 = abc_2885_new_n2229
* NET   745 = abc_2885_new_n2228
* NET   746 = abc_2885_new_n2226
* NET   747 = abc_2885_new_n2224
* NET   748 = abc_2885_new_n2223
* NET   749 = abc_2885_new_n2221
* NET   750 = abc_2885_new_n2220
* NET   751 = abc_2885_new_n2216
* NET   752 = abc_2885_new_n2215
* NET   753 = abc_2885_new_n2214
* NET   754 = abc_2885_new_n2212
* NET   755 = abc_2885_new_n2211
* NET   756 = abc_2885_new_n2210
* NET   757 = abc_2885_new_n2209
* NET   758 = abc_2885_new_n2207
* NET   759 = abc_2885_new_n2206
* NET   760 = abc_2885_new_n2205
* NET   761 = abc_2885_new_n2203
* NET   762 = abc_2885_new_n2202
* NET   763 = abc_2885_new_n2201
* NET   764 = abc_2885_new_n2200
* NET   765 = abc_2885_new_n2198
* NET   766 = abc_2885_new_n2197
* NET   767 = abc_2885_new_n2196
* NET   768 = abc_2885_new_n2194
* NET   769 = abc_2885_new_n2193
* NET   770 = abc_2885_new_n2192
* NET   771 = abc_2885_new_n2190
* NET   772 = abc_2885_new_n2189
* NET   773 = abc_2885_new_n2188
* NET   774 = abc_2885_new_n2186
* NET   775 = abc_2885_new_n2185
* NET   776 = abc_2885_new_n2184
* NET   777 = abc_2885_new_n2182
* NET   778 = abc_2885_new_n2181
* NET   779 = abc_2885_new_n2180
* NET   780 = abc_2885_new_n2178
* NET   781 = abc_2885_new_n2177
* NET   782 = abc_2885_new_n2176
* NET   783 = abc_2885_new_n2175
* NET   784 = abc_2885_new_n2173
* NET   785 = abc_2885_new_n2172
* NET   786 = abc_2885_new_n2171
* NET   787 = abc_2885_new_n2169
* NET   788 = abc_2885_new_n2168
* NET   789 = abc_2885_new_n2167
* NET   790 = abc_2885_new_n2165
* NET   791 = abc_2885_new_n2164
* NET   792 = abc_2885_new_n2163
* NET   793 = abc_2885_new_n2161
* NET   794 = abc_2885_new_n2160
* NET   795 = abc_2885_new_n2159
* NET   796 = abc_2885_new_n2158
* NET   797 = abc_2885_new_n2156
* NET   798 = abc_2885_new_n2155
* NET   799 = abc_2885_new_n2154
* NET   800 = abc_2885_new_n2152
* NET   801 = abc_2885_new_n2151
* NET   802 = abc_2885_new_n2150
* NET   803 = abc_2885_new_n2149
* NET   804 = abc_2885_new_n2147
* NET   805 = abc_2885_new_n2146
* NET   806 = abc_2885_new_n2145
* NET   807 = abc_2885_new_n2143
* NET   808 = abc_2885_new_n2142
* NET   809 = abc_2885_new_n2141
* NET   810 = abc_2885_new_n2139
* NET   811 = abc_2885_new_n2138
* NET   812 = abc_2885_new_n2137
* NET   813 = abc_2885_new_n2135
* NET   814 = abc_2885_new_n2134
* NET   815 = abc_2885_new_n2133
* NET   816 = abc_2885_new_n2131
* NET   817 = abc_2885_new_n2130
* NET   818 = abc_2885_new_n2129
* NET   819 = abc_2885_new_n2127
* NET   820 = abc_2885_new_n2126
* NET   821 = abc_2885_new_n2125
* NET   822 = abc_2885_new_n2123
* NET   823 = abc_2885_new_n2122
* NET   824 = abc_2885_new_n2121
* NET   825 = abc_2885_new_n2119
* NET   826 = abc_2885_new_n2118
* NET   827 = abc_2885_new_n2117
* NET   828 = abc_2885_new_n2115
* NET   829 = abc_2885_new_n2114
* NET   830 = abc_2885_new_n2113
* NET   831 = abc_2885_new_n2111
* NET   832 = abc_2885_new_n2110
* NET   833 = abc_2885_new_n2109
* NET   834 = abc_2885_new_n2108
* NET   835 = abc_2885_new_n2106
* NET   836 = abc_2885_new_n2105
* NET   837 = abc_2885_new_n2104
* NET   838 = abc_2885_new_n2102
* NET   839 = abc_2885_new_n2101
* NET   840 = abc_2885_new_n2100
* NET   841 = abc_2885_new_n2099
* NET   842 = abc_2885_new_n2097
* NET   843 = abc_2885_new_n2096
* NET   844 = abc_2885_new_n2095
* NET   845 = abc_2885_new_n2093
* NET   846 = abc_2885_new_n2092
* NET   847 = abc_2885_new_n2091
* NET   848 = abc_2885_new_n2090
* NET   849 = abc_2885_new_n2088
* NET   850 = abc_2885_new_n2087
* NET   851 = abc_2885_new_n2086
* NET   852 = abc_2885_new_n2084
* NET   853 = abc_2885_new_n2083
* NET   854 = abc_2885_new_n2082
* NET   855 = abc_2885_new_n2081
* NET   856 = abc_2885_new_n2079
* NET   857 = abc_2885_new_n2078
* NET   858 = abc_2885_new_n2077
* NET   859 = abc_2885_new_n2075
* NET   860 = abc_2885_new_n2074
* NET   861 = abc_2885_new_n2073
* NET   862 = abc_2885_new_n2072
* NET   863 = abc_2885_new_n2070
* NET   864 = abc_2885_new_n2069
* NET   865 = abc_2885_new_n2068
* NET   866 = abc_2885_new_n2066
* NET   867 = abc_2885_new_n2065
* NET   868 = abc_2885_new_n2064
* NET   869 = abc_2885_new_n2063
* NET   870 = abc_2885_new_n2061
* NET   871 = abc_2885_new_n2060
* NET   872 = abc_2885_new_n2059
* NET   873 = abc_2885_new_n2057
* NET   874 = abc_2885_new_n2056
* NET   875 = abc_2885_new_n2055
* NET   876 = abc_2885_new_n2053
* NET   877 = abc_2885_new_n2052
* NET   878 = abc_2885_new_n2051
* NET   879 = abc_2885_new_n2049
* NET   880 = abc_2885_new_n2048
* NET   881 = abc_2885_new_n2047
* NET   882 = abc_2885_new_n2045
* NET   883 = abc_2885_new_n2044
* NET   884 = abc_2885_new_n2043
* NET   885 = abc_2885_new_n2041
* NET   886 = abc_2885_new_n2040
* NET   887 = abc_2885_new_n2039
* NET   888 = abc_2885_new_n2037
* NET   889 = abc_2885_new_n2036
* NET   890 = abc_2885_new_n2035
* NET   891 = abc_2885_new_n2033
* NET   892 = abc_2885_new_n2032
* NET   893 = abc_2885_new_n2031
* NET   894 = abc_2885_new_n2029
* NET   895 = abc_2885_new_n2028
* NET   896 = abc_2885_new_n2027
* NET   897 = abc_2885_new_n2025
* NET   898 = abc_2885_new_n2024
* NET   899 = abc_2885_new_n2023
* NET   900 = abc_2885_new_n2022
* NET   901 = abc_2885_new_n2020
* NET   902 = abc_2885_new_n2019
* NET   903 = abc_2885_new_n2018
* NET   904 = abc_2885_new_n2016
* NET   905 = abc_2885_new_n2015
* NET   906 = abc_2885_new_n2014
* NET   907 = abc_2885_new_n2013
* NET   908 = abc_2885_new_n2011
* NET   909 = abc_2885_new_n2010
* NET   910 = abc_2885_new_n2009
* NET   911 = abc_2885_new_n2007
* NET   912 = abc_2885_new_n2006
* NET   913 = abc_2885_new_n2005
* NET   914 = abc_2885_new_n2004
* NET   915 = abc_2885_new_n2002
* NET   916 = abc_2885_new_n2001
* NET   917 = abc_2885_new_n2000
* NET   918 = abc_2885_new_n1998
* NET   919 = abc_2885_new_n1997
* NET   920 = abc_2885_new_n1996
* NET   921 = abc_2885_new_n1995
* NET   922 = abc_2885_new_n1993
* NET   923 = abc_2885_new_n1992
* NET   924 = abc_2885_new_n1991
* NET   925 = abc_2885_new_n1989
* NET   926 = abc_2885_new_n1988
* NET   927 = abc_2885_new_n1987
* NET   928 = abc_2885_new_n1985
* NET   929 = abc_2885_new_n1984
* NET   930 = abc_2885_new_n1983
* NET   931 = abc_2885_new_n1981
* NET   932 = abc_2885_new_n1980
* NET   933 = abc_2885_new_n1979
* NET   934 = abc_2885_new_n1978
* NET   935 = abc_2885_new_n1976
* NET   936 = abc_2885_new_n1975
* NET   937 = abc_2885_new_n1974
* NET   938 = abc_2885_new_n1972
* NET   939 = abc_2885_new_n1971
* NET   940 = abc_2885_new_n1970
* NET   941 = abc_2885_new_n1968
* NET   942 = abc_2885_new_n1967
* NET   943 = abc_2885_new_n1966
* NET   944 = abc_2885_new_n1964
* NET   945 = abc_2885_new_n1963
* NET   946 = abc_2885_new_n1962
* NET   947 = abc_2885_new_n1960
* NET   948 = abc_2885_new_n1959
* NET   949 = abc_2885_new_n1958
* NET   950 = abc_2885_new_n1956
* NET   951 = abc_2885_new_n1955
* NET   952 = abc_2885_new_n1954
* NET   953 = abc_2885_new_n1953
* NET   954 = abc_2885_new_n1951
* NET   955 = abc_2885_new_n1950
* NET   956 = abc_2885_new_n1949
* NET   957 = abc_2885_new_n1947
* NET   958 = abc_2885_new_n1946
* NET   959 = abc_2885_new_n1945
* NET   960 = abc_2885_new_n1943
* NET   961 = abc_2885_new_n1942
* NET   962 = abc_2885_new_n1941
* NET   963 = abc_2885_new_n1939
* NET   964 = abc_2885_new_n1938
* NET   965 = abc_2885_new_n1937
* NET   966 = abc_2885_new_n1936
* NET   967 = abc_2885_new_n1934
* NET   968 = abc_2885_new_n1933
* NET   969 = abc_2885_new_n1932
* NET   970 = abc_2885_new_n1930
* NET   971 = abc_2885_new_n1929
* NET   972 = abc_2885_new_n1928
* NET   973 = abc_2885_new_n1927
* NET   974 = abc_2885_new_n1925
* NET   975 = abc_2885_new_n1924
* NET   976 = abc_2885_new_n1923
* NET   977 = abc_2885_new_n1921
* NET   978 = abc_2885_new_n1920
* NET   979 = abc_2885_new_n1919
* NET   980 = abc_2885_new_n1917
* NET   981 = abc_2885_new_n1916
* NET   982 = abc_2885_new_n1915
* NET   983 = abc_2885_new_n1913
* NET   984 = abc_2885_new_n1912
* NET   985 = abc_2885_new_n1911
* NET   986 = abc_2885_new_n1909
* NET   987 = abc_2885_new_n1908
* NET   988 = abc_2885_new_n1907
* NET   989 = abc_2885_new_n1905
* NET   990 = abc_2885_new_n1904
* NET   991 = abc_2885_new_n1903
* NET   992 = abc_2885_new_n1902
* NET   993 = abc_2885_new_n1900
* NET   994 = abc_2885_new_n1899
* NET   995 = abc_2885_new_n1898
* NET   996 = abc_2885_new_n1896
* NET   997 = abc_2885_new_n1895
* NET   998 = abc_2885_new_n1894
* NET   999 = abc_2885_new_n1892
* NET  1000 = abc_2885_new_n1891
* NET  1001 = abc_2885_new_n1890
* NET  1002 = abc_2885_new_n1888
* NET  1003 = abc_2885_new_n1887
* NET  1004 = abc_2885_new_n1886
* NET  1005 = abc_2885_new_n1885
* NET  1006 = abc_2885_new_n1883
* NET  1007 = abc_2885_new_n1882
* NET  1008 = abc_2885_new_n1881
* NET  1009 = abc_2885_new_n1879
* NET  1010 = abc_2885_new_n1878
* NET  1011 = abc_2885_new_n1877
* NET  1012 = abc_2885_new_n1876
* NET  1013 = abc_2885_new_n1874
* NET  1014 = abc_2885_new_n1873
* NET  1015 = abc_2885_new_n1872
* NET  1016 = abc_2885_new_n1870
* NET  1017 = abc_2885_new_n1869
* NET  1018 = abc_2885_new_n1868
* NET  1019 = abc_2885_new_n1866
* NET  1020 = abc_2885_new_n1865
* NET  1021 = abc_2885_new_n1864
* NET  1022 = abc_2885_new_n1862
* NET  1023 = abc_2885_new_n1861
* NET  1024 = abc_2885_new_n1860
* NET  1025 = abc_2885_new_n1858
* NET  1026 = abc_2885_new_n1857
* NET  1027 = abc_2885_new_n1856
* NET  1028 = abc_2885_new_n1854
* NET  1029 = abc_2885_new_n1853
* NET  1030 = abc_2885_new_n1852
* NET  1031 = abc_2885_new_n1850
* NET  1032 = abc_2885_new_n1849
* NET  1033 = abc_2885_new_n1848
* NET  1034 = abc_2885_new_n1846
* NET  1035 = abc_2885_new_n1845
* NET  1036 = abc_2885_new_n1844
* NET  1037 = abc_2885_new_n1842
* NET  1038 = abc_2885_new_n1841
* NET  1039 = abc_2885_new_n1840
* NET  1040 = abc_2885_new_n1838
* NET  1041 = abc_2885_new_n1837
* NET  1042 = abc_2885_new_n1836
* NET  1043 = abc_2885_new_n1835
* NET  1044 = abc_2885_new_n1833
* NET  1045 = abc_2885_new_n1832
* NET  1046 = abc_2885_new_n1831
* NET  1047 = abc_2885_new_n1829
* NET  1048 = abc_2885_new_n1828
* NET  1049 = abc_2885_new_n1827
* NET  1050 = abc_2885_new_n1826
* NET  1051 = abc_2885_new_n1824
* NET  1052 = abc_2885_new_n1823
* NET  1053 = abc_2885_new_n1822
* NET  1054 = abc_2885_new_n1820
* NET  1055 = abc_2885_new_n1819
* NET  1056 = abc_2885_new_n1818
* NET  1057 = abc_2885_new_n1817
* NET  1058 = abc_2885_new_n1815
* NET  1059 = abc_2885_new_n1814
* NET  1060 = abc_2885_new_n1813
* NET  1061 = abc_2885_new_n1811
* NET  1062 = abc_2885_new_n1810
* NET  1063 = abc_2885_new_n1809
* NET  1064 = abc_2885_new_n1808
* NET  1065 = abc_2885_new_n1806
* NET  1066 = abc_2885_new_n1805
* NET  1067 = abc_2885_new_n1804
* NET  1068 = abc_2885_new_n1802
* NET  1069 = abc_2885_new_n1801
* NET  1070 = abc_2885_new_n1800
* NET  1071 = abc_2885_new_n1799
* NET  1072 = abc_2885_new_n1797
* NET  1073 = abc_2885_new_n1796
* NET  1074 = abc_2885_new_n1795
* NET  1075 = abc_2885_new_n1793
* NET  1076 = abc_2885_new_n1792
* NET  1077 = abc_2885_new_n1791
* NET  1078 = abc_2885_new_n1790
* NET  1079 = abc_2885_new_n1788
* NET  1080 = abc_2885_new_n1787
* NET  1081 = abc_2885_new_n1786
* NET  1082 = abc_2885_new_n1784
* NET  1083 = abc_2885_new_n1783
* NET  1084 = abc_2885_new_n1782
* NET  1085 = abc_2885_new_n1780
* NET  1086 = abc_2885_new_n1779
* NET  1087 = abc_2885_new_n1778
* NET  1088 = abc_2885_new_n1776
* NET  1089 = abc_2885_new_n1775
* NET  1090 = abc_2885_new_n1774
* NET  1091 = abc_2885_new_n1772
* NET  1092 = abc_2885_new_n1771
* NET  1093 = abc_2885_new_n1770
* NET  1094 = abc_2885_new_n1768
* NET  1095 = abc_2885_new_n1767
* NET  1096 = abc_2885_new_n1766
* NET  1097 = abc_2885_new_n1764
* NET  1098 = abc_2885_new_n1763
* NET  1099 = abc_2885_new_n1762
* NET  1100 = abc_2885_new_n1760
* NET  1101 = abc_2885_new_n1759
* NET  1102 = abc_2885_new_n1758
* NET  1103 = abc_2885_new_n1756
* NET  1104 = abc_2885_new_n1755
* NET  1105 = abc_2885_new_n1754
* NET  1106 = abc_2885_new_n1752
* NET  1107 = abc_2885_new_n1751
* NET  1108 = abc_2885_new_n1750
* NET  1109 = abc_2885_new_n1749
* NET  1110 = abc_2885_new_n1747
* NET  1111 = abc_2885_new_n1746
* NET  1112 = abc_2885_new_n1745
* NET  1113 = abc_2885_new_n1743
* NET  1114 = abc_2885_new_n1742
* NET  1115 = abc_2885_new_n1741
* NET  1116 = abc_2885_new_n1740
* NET  1117 = abc_2885_new_n1738
* NET  1118 = abc_2885_new_n1737
* NET  1119 = abc_2885_new_n1736
* NET  1120 = abc_2885_new_n1734
* NET  1121 = abc_2885_new_n1733
* NET  1122 = abc_2885_new_n1732
* NET  1123 = abc_2885_new_n1731
* NET  1124 = abc_2885_new_n1729
* NET  1125 = abc_2885_new_n1728
* NET  1126 = abc_2885_new_n1727
* NET  1127 = abc_2885_new_n1725
* NET  1128 = abc_2885_new_n1724
* NET  1129 = abc_2885_new_n1723
* NET  1130 = abc_2885_new_n1722
* NET  1131 = abc_2885_new_n1720
* NET  1132 = abc_2885_new_n1719
* NET  1133 = abc_2885_new_n1718
* NET  1134 = abc_2885_new_n1716
* NET  1135 = abc_2885_new_n1715
* NET  1136 = abc_2885_new_n1714
* NET  1137 = abc_2885_new_n1712
* NET  1138 = abc_2885_new_n1711
* NET  1139 = abc_2885_new_n1710
* NET  1140 = abc_2885_new_n1708
* NET  1141 = abc_2885_new_n1707
* NET  1142 = abc_2885_new_n1706
* NET  1143 = abc_2885_new_n1705
* NET  1144 = abc_2885_new_n1703
* NET  1145 = abc_2885_new_n1702
* NET  1146 = abc_2885_new_n1701
* NET  1147 = abc_2885_new_n1699
* NET  1148 = abc_2885_new_n1698
* NET  1149 = abc_2885_new_n1697
* NET  1150 = abc_2885_new_n1695
* NET  1151 = abc_2885_new_n1694
* NET  1152 = abc_2885_new_n1693
* NET  1153 = abc_2885_new_n1691
* NET  1154 = abc_2885_new_n1690
* NET  1155 = abc_2885_new_n1689
* NET  1156 = abc_2885_new_n1687
* NET  1157 = abc_2885_new_n1686
* NET  1158 = abc_2885_new_n1685
* NET  1159 = abc_2885_new_n1683
* NET  1160 = abc_2885_new_n1682
* NET  1161 = abc_2885_new_n1681
* NET  1162 = abc_2885_new_n1680
* NET  1163 = abc_2885_new_n1678
* NET  1164 = abc_2885_new_n1677
* NET  1165 = abc_2885_new_n1676
* NET  1166 = abc_2885_new_n1674
* NET  1167 = abc_2885_new_n1673
* NET  1168 = abc_2885_new_n1672
* NET  1169 = abc_2885_new_n1670
* NET  1170 = abc_2885_new_n1669
* NET  1171 = abc_2885_new_n1668
* NET  1172 = abc_2885_new_n1666
* NET  1173 = abc_2885_new_n1665
* NET  1174 = abc_2885_new_n1664
* NET  1175 = abc_2885_new_n1663
* NET  1176 = abc_2885_new_n1661
* NET  1177 = abc_2885_new_n1660
* NET  1178 = abc_2885_new_n1659
* NET  1179 = abc_2885_new_n1657
* NET  1180 = abc_2885_new_n1656
* NET  1181 = abc_2885_new_n1655
* NET  1182 = abc_2885_new_n1654
* NET  1183 = abc_2885_new_n1652
* NET  1184 = abc_2885_new_n1651
* NET  1185 = abc_2885_new_n1650
* NET  1186 = abc_2885_new_n1648
* NET  1187 = abc_2885_new_n1647
* NET  1188 = abc_2885_new_n1646
* NET  1189 = abc_2885_new_n1644
* NET  1190 = abc_2885_new_n1643
* NET  1191 = abc_2885_new_n1642
* NET  1192 = abc_2885_new_n1640
* NET  1193 = abc_2885_new_n1639
* NET  1194 = abc_2885_new_n1638
* NET  1195 = abc_2885_new_n1636
* NET  1196 = abc_2885_new_n1635
* NET  1197 = abc_2885_new_n1634
* NET  1198 = abc_2885_new_n1632
* NET  1199 = abc_2885_new_n1631
* NET  1200 = abc_2885_new_n1630
* NET  1201 = abc_2885_new_n1629
* NET  1202 = abc_2885_new_n1627
* NET  1203 = abc_2885_new_n1626
* NET  1204 = abc_2885_new_n1625
* NET  1205 = abc_2885_new_n1623
* NET  1206 = abc_2885_new_n1622
* NET  1207 = abc_2885_new_n1621
* NET  1208 = abc_2885_new_n1620
* NET  1209 = abc_2885_new_n1618
* NET  1210 = abc_2885_new_n1617
* NET  1211 = abc_2885_new_n1616
* NET  1212 = abc_2885_new_n1614
* NET  1213 = abc_2885_new_n1613
* NET  1214 = abc_2885_new_n1612
* NET  1215 = abc_2885_new_n1611
* NET  1216 = abc_2885_new_n1609
* NET  1217 = abc_2885_new_n1608
* NET  1218 = abc_2885_new_n1607
* NET  1219 = abc_2885_new_n1605
* NET  1220 = abc_2885_new_n1604
* NET  1221 = abc_2885_new_n1603
* NET  1222 = abc_2885_new_n1602
* NET  1223 = abc_2885_new_n1600
* NET  1224 = abc_2885_new_n1599
* NET  1225 = abc_2885_new_n1598
* NET  1226 = abc_2885_new_n1596
* NET  1227 = abc_2885_new_n1595
* NET  1228 = abc_2885_new_n1594
* NET  1229 = abc_2885_new_n1592
* NET  1230 = abc_2885_new_n1591
* NET  1231 = abc_2885_new_n1590
* NET  1232 = abc_2885_new_n1588
* NET  1233 = abc_2885_new_n1587
* NET  1234 = abc_2885_new_n1586
* NET  1235 = abc_2885_new_n1584
* NET  1236 = abc_2885_new_n1583
* NET  1237 = abc_2885_new_n1582
* NET  1238 = abc_2885_new_n1580
* NET  1239 = abc_2885_new_n1579
* NET  1240 = abc_2885_new_n1578
* NET  1241 = abc_2885_new_n1576
* NET  1242 = abc_2885_new_n1575
* NET  1243 = abc_2885_new_n1574
* NET  1244 = abc_2885_new_n1572
* NET  1245 = abc_2885_new_n1571
* NET  1246 = abc_2885_new_n1570
* NET  1247 = abc_2885_new_n1568
* NET  1248 = abc_2885_new_n1567
* NET  1249 = abc_2885_new_n1566
* NET  1250 = abc_2885_new_n1564
* NET  1251 = abc_2885_new_n1563
* NET  1252 = abc_2885_new_n1562
* NET  1253 = abc_2885_new_n1561
* NET  1254 = abc_2885_new_n1559
* NET  1255 = abc_2885_new_n1558
* NET  1256 = abc_2885_new_n1557
* NET  1257 = abc_2885_new_n1555
* NET  1258 = abc_2885_new_n1554
* NET  1259 = abc_2885_new_n1553
* NET  1260 = abc_2885_new_n1552
* NET  1261 = abc_2885_new_n1550
* NET  1262 = abc_2885_new_n1549
* NET  1263 = abc_2885_new_n1548
* NET  1264 = abc_2885_new_n1546
* NET  1265 = abc_2885_new_n1545
* NET  1266 = abc_2885_new_n1544
* NET  1267 = abc_2885_new_n1543
* NET  1268 = abc_2885_new_n1541
* NET  1269 = abc_2885_new_n1540
* NET  1270 = abc_2885_new_n1539
* NET  1271 = abc_2885_new_n1537
* NET  1272 = abc_2885_new_n1536
* NET  1273 = abc_2885_new_n1535
* NET  1274 = abc_2885_new_n1534
* NET  1275 = abc_2885_new_n1532
* NET  1276 = abc_2885_new_n1531
* NET  1277 = abc_2885_new_n1530
* NET  1278 = abc_2885_new_n1528
* NET  1279 = abc_2885_new_n1527
* NET  1280 = abc_2885_new_n1526
* NET  1281 = abc_2885_new_n1525
* NET  1282 = abc_2885_new_n1523
* NET  1283 = abc_2885_new_n1522
* NET  1284 = abc_2885_new_n1521
* NET  1285 = abc_2885_new_n1519
* NET  1286 = abc_2885_new_n1518
* NET  1287 = abc_2885_new_n1517
* NET  1288 = abc_2885_new_n1516
* NET  1289 = abc_2885_new_n1514
* NET  1290 = abc_2885_new_n1513
* NET  1291 = abc_2885_new_n1512
* NET  1292 = abc_2885_new_n1510
* NET  1293 = abc_2885_new_n1509
* NET  1294 = abc_2885_new_n1508
* NET  1295 = abc_2885_new_n1506
* NET  1296 = abc_2885_new_n1505
* NET  1297 = abc_2885_new_n1504
* NET  1298 = abc_2885_new_n1502
* NET  1299 = abc_2885_new_n1501
* NET  1300 = abc_2885_new_n1500
* NET  1301 = abc_2885_new_n1498
* NET  1302 = abc_2885_new_n1497
* NET  1303 = abc_2885_new_n1496
* NET  1304 = abc_2885_new_n1494
* NET  1305 = abc_2885_new_n1493
* NET  1306 = abc_2885_new_n1492
* NET  1307 = abc_2885_new_n1490
* NET  1308 = abc_2885_new_n1489
* NET  1309 = abc_2885_new_n1488
* NET  1310 = abc_2885_new_n1486
* NET  1311 = abc_2885_new_n1485
* NET  1312 = abc_2885_new_n1484
* NET  1313 = abc_2885_new_n1483
* NET  1314 = abc_2885_new_n1481
* NET  1315 = abc_2885_new_n1480
* NET  1316 = abc_2885_new_n1479
* NET  1317 = abc_2885_new_n1477
* NET  1318 = abc_2885_new_n1476
* NET  1319 = abc_2885_new_n1475
* NET  1320 = abc_2885_new_n1474
* NET  1321 = abc_2885_new_n1472
* NET  1322 = abc_2885_new_n1471
* NET  1323 = abc_2885_new_n1470
* NET  1324 = abc_2885_new_n1468
* NET  1325 = abc_2885_new_n1467
* NET  1326 = abc_2885_new_n1466
* NET  1327 = abc_2885_new_n1465
* NET  1328 = abc_2885_new_n1463
* NET  1329 = abc_2885_new_n1462
* NET  1330 = abc_2885_new_n1461
* NET  1331 = abc_2885_new_n1459
* NET  1332 = abc_2885_new_n1458
* NET  1333 = abc_2885_new_n1457
* NET  1334 = abc_2885_new_n1456
* NET  1335 = abc_2885_new_n1454
* NET  1336 = abc_2885_new_n1453
* NET  1337 = abc_2885_new_n1452
* NET  1338 = abc_2885_new_n1450
* NET  1339 = abc_2885_new_n1449
* NET  1340 = abc_2885_new_n1448
* NET  1341 = abc_2885_new_n1446
* NET  1342 = abc_2885_new_n1445
* NET  1343 = abc_2885_new_n1444
* NET  1344 = abc_2885_new_n1442
* NET  1345 = abc_2885_new_n1441
* NET  1346 = abc_2885_new_n1440
* NET  1347 = abc_2885_new_n1438
* NET  1348 = abc_2885_new_n1437
* NET  1349 = abc_2885_new_n1436
* NET  1350 = abc_2885_new_n1434
* NET  1351 = abc_2885_new_n1433
* NET  1352 = abc_2885_new_n1432
* NET  1353 = abc_2885_new_n1431
* NET  1354 = abc_2885_new_n1429
* NET  1355 = abc_2885_new_n1428
* NET  1356 = abc_2885_new_n1427
* NET  1357 = abc_2885_new_n1425
* NET  1358 = abc_2885_new_n1424
* NET  1359 = abc_2885_new_n1423
* NET  1360 = abc_2885_new_n1421
* NET  1361 = abc_2885_new_n1420
* NET  1362 = abc_2885_new_n1419
* NET  1363 = abc_2885_new_n1417
* NET  1364 = abc_2885_new_n1416
* NET  1365 = abc_2885_new_n1415
* NET  1366 = abc_2885_new_n1413
* NET  1367 = abc_2885_new_n1412
* NET  1368 = abc_2885_new_n1411
* NET  1369 = abc_2885_new_n1409
* NET  1370 = abc_2885_new_n1408
* NET  1371 = abc_2885_new_n1407
* NET  1372 = abc_2885_new_n1405
* NET  1373 = abc_2885_new_n1404
* NET  1374 = abc_2885_new_n1403
* NET  1375 = abc_2885_new_n1401
* NET  1376 = abc_2885_new_n1400
* NET  1377 = abc_2885_new_n1399
* NET  1378 = abc_2885_new_n1397
* NET  1379 = abc_2885_new_n1396
* NET  1380 = abc_2885_new_n1395
* NET  1381 = abc_2885_new_n1393
* NET  1382 = abc_2885_new_n1392
* NET  1383 = abc_2885_new_n1391
* NET  1384 = abc_2885_new_n1390
* NET  1385 = abc_2885_new_n1388
* NET  1386 = abc_2885_new_n1387
* NET  1387 = abc_2885_new_n1386
* NET  1388 = abc_2885_new_n1384
* NET  1389 = abc_2885_new_n1383
* NET  1390 = abc_2885_new_n1382
* NET  1391 = abc_2885_new_n1381
* NET  1392 = abc_2885_new_n1379
* NET  1393 = abc_2885_new_n1378
* NET  1394 = abc_2885_new_n1377
* NET  1395 = abc_2885_new_n1375
* NET  1396 = abc_2885_new_n1374
* NET  1397 = abc_2885_new_n1373
* NET  1398 = abc_2885_new_n1371
* NET  1399 = abc_2885_new_n1370
* NET  1400 = abc_2885_new_n1369
* NET  1401 = abc_2885_new_n1367
* NET  1402 = abc_2885_new_n1366
* NET  1403 = abc_2885_new_n1365
* NET  1404 = abc_2885_new_n1363
* NET  1405 = abc_2885_new_n1362
* NET  1406 = abc_2885_new_n1361
* NET  1407 = abc_2885_new_n1359
* NET  1408 = abc_2885_new_n1358
* NET  1409 = abc_2885_new_n1357
* NET  1410 = abc_2885_new_n1356
* NET  1411 = abc_2885_new_n1354
* NET  1412 = abc_2885_new_n1353
* NET  1413 = abc_2885_new_n1352
* NET  1414 = abc_2885_new_n1350
* NET  1415 = abc_2885_new_n1349
* NET  1416 = abc_2885_new_n1348
* NET  1417 = abc_2885_new_n1347
* NET  1418 = abc_2885_new_n1345
* NET  1419 = abc_2885_new_n1344
* NET  1420 = abc_2885_new_n1343
* NET  1421 = abc_2885_new_n1341
* NET  1422 = abc_2885_new_n1340
* NET  1423 = abc_2885_new_n1339
* NET  1424 = abc_2885_new_n1338
* NET  1425 = abc_2885_new_n1336
* NET  1426 = abc_2885_new_n1335
* NET  1427 = abc_2885_new_n1334
* NET  1428 = abc_2885_new_n1332
* NET  1429 = abc_2885_new_n1331
* NET  1430 = abc_2885_new_n1330
* NET  1431 = abc_2885_new_n1329
* NET  1432 = abc_2885_new_n1327
* NET  1433 = abc_2885_new_n1326
* NET  1434 = abc_2885_new_n1325
* NET  1435 = abc_2885_new_n1323
* NET  1436 = abc_2885_new_n1322
* NET  1437 = abc_2885_new_n1321
* NET  1438 = abc_2885_new_n1319
* NET  1439 = abc_2885_new_n1318
* NET  1440 = abc_2885_new_n1317
* NET  1441 = abc_2885_new_n1315
* NET  1442 = abc_2885_new_n1314
* NET  1443 = abc_2885_new_n1313
* NET  1444 = abc_2885_new_n1311
* NET  1445 = abc_2885_new_n1310
* NET  1446 = abc_2885_new_n1309
* NET  1447 = abc_2885_new_n1307
* NET  1448 = abc_2885_new_n1306
* NET  1449 = abc_2885_new_n1305
* NET  1450 = abc_2885_new_n1303
* NET  1451 = abc_2885_new_n1302
* NET  1452 = abc_2885_new_n1301
* NET  1453 = abc_2885_new_n1299
* NET  1454 = abc_2885_new_n1298
* NET  1455 = abc_2885_new_n1297
* NET  1456 = abc_2885_new_n1295
* NET  1457 = abc_2885_new_n1294
* NET  1458 = abc_2885_new_n1293
* NET  1459 = abc_2885_new_n1291
* NET  1460 = abc_2885_new_n1290
* NET  1461 = abc_2885_new_n1289
* NET  1462 = abc_2885_new_n1288
* NET  1463 = abc_2885_new_n1286
* NET  1464 = abc_2885_new_n1285
* NET  1465 = abc_2885_new_n1284
* NET  1466 = abc_2885_new_n1282
* NET  1467 = abc_2885_new_n1281
* NET  1468 = abc_2885_new_n1280
* NET  1469 = abc_2885_new_n1279
* NET  1470 = abc_2885_new_n1277
* NET  1471 = abc_2885_new_n1276
* NET  1472 = abc_2885_new_n1275
* NET  1473 = abc_2885_new_n1273
* NET  1474 = abc_2885_new_n1272
* NET  1475 = abc_2885_new_n1271
* NET  1476 = abc_2885_new_n1270
* NET  1477 = abc_2885_new_n1268
* NET  1478 = abc_2885_new_n1267
* NET  1479 = abc_2885_new_n1266
* NET  1480 = abc_2885_new_n1264
* NET  1481 = abc_2885_new_n1263
* NET  1482 = abc_2885_new_n1262
* NET  1483 = abc_2885_new_n1261
* NET  1484 = abc_2885_new_n1259
* NET  1485 = abc_2885_new_n1258
* NET  1486 = abc_2885_new_n1257
* NET  1487 = abc_2885_new_n1255
* NET  1488 = abc_2885_new_n1254
* NET  1489 = abc_2885_new_n1253
* NET  1490 = abc_2885_new_n1252
* NET  1491 = abc_2885_new_n1250
* NET  1492 = abc_2885_new_n1249
* NET  1493 = abc_2885_new_n1248
* NET  1494 = abc_2885_new_n1246
* NET  1495 = abc_2885_new_n1245
* NET  1496 = abc_2885_new_n1244
* NET  1497 = abc_2885_new_n1243
* NET  1498 = abc_2885_new_n1241
* NET  1499 = abc_2885_new_n1240
* NET  1500 = abc_2885_new_n1239
* NET  1501 = abc_2885_new_n1237
* NET  1502 = abc_2885_new_n1236
* NET  1503 = abc_2885_new_n1235
* NET  1504 = abc_2885_new_n1233
* NET  1505 = abc_2885_new_n1232
* NET  1506 = abc_2885_new_n1231
* NET  1507 = abc_2885_new_n1229
* NET  1508 = abc_2885_new_n1228
* NET  1509 = abc_2885_new_n1227
* NET  1510 = abc_2885_new_n1225
* NET  1511 = abc_2885_new_n1224
* NET  1512 = abc_2885_new_n1223
* NET  1513 = abc_2885_new_n1221
* NET  1514 = abc_2885_new_n1220
* NET  1515 = abc_2885_new_n1219
* NET  1516 = abc_2885_new_n1217
* NET  1517 = abc_2885_new_n1216
* NET  1518 = abc_2885_new_n1215
* NET  1519 = abc_2885_new_n1213
* NET  1520 = abc_2885_new_n1212
* NET  1521 = abc_2885_new_n1211
* NET  1522 = abc_2885_new_n1210
* NET  1523 = abc_2885_new_n1208
* NET  1524 = abc_2885_new_n1207
* NET  1525 = abc_2885_new_n1206
* NET  1526 = abc_2885_new_n1204
* NET  1527 = abc_2885_new_n1203
* NET  1528 = abc_2885_new_n1202
* NET  1529 = abc_2885_new_n1201
* NET  1530 = abc_2885_new_n1199
* NET  1531 = abc_2885_new_n1198
* NET  1532 = abc_2885_new_n1197
* NET  1533 = abc_2885_new_n1195
* NET  1534 = abc_2885_new_n1194
* NET  1535 = abc_2885_new_n1193
* NET  1536 = abc_2885_new_n1192
* NET  1537 = abc_2885_new_n1190
* NET  1538 = abc_2885_new_n1189
* NET  1539 = abc_2885_new_n1188
* NET  1540 = abc_2885_new_n1186
* NET  1541 = abc_2885_new_n1185
* NET  1542 = abc_2885_new_n1184
* NET  1543 = abc_2885_new_n1183
* NET  1544 = abc_2885_new_n1181
* NET  1545 = abc_2885_new_n1180
* NET  1546 = abc_2885_new_n1179
* NET  1547 = abc_2885_new_n1177
* NET  1548 = abc_2885_new_n1176
* NET  1549 = abc_2885_new_n1175
* NET  1550 = abc_2885_new_n1173
* NET  1551 = abc_2885_new_n1172
* NET  1552 = abc_2885_new_n1171
* NET  1553 = abc_2885_new_n1169
* NET  1554 = abc_2885_new_n1168
* NET  1555 = abc_2885_new_n1167
* NET  1556 = abc_2885_new_n1165
* NET  1557 = abc_2885_new_n1164
* NET  1558 = abc_2885_new_n1163
* NET  1559 = abc_2885_new_n1161
* NET  1560 = abc_2885_new_n1160
* NET  1561 = abc_2885_new_n1159
* NET  1562 = abc_2885_new_n1158
* NET  1563 = abc_2885_new_n1156
* NET  1564 = abc_2885_new_n1155
* NET  1565 = abc_2885_new_n1154
* NET  1566 = abc_2885_new_n1152
* NET  1567 = abc_2885_new_n1151
* NET  1568 = abc_2885_new_n1150
* NET  1569 = abc_2885_new_n1148
* NET  1570 = abc_2885_new_n1147
* NET  1571 = abc_2885_new_n1146
* NET  1572 = abc_2885_new_n1144
* NET  1573 = abc_2885_new_n1143
* NET  1574 = abc_2885_new_n1142
* NET  1575 = abc_2885_new_n1140
* NET  1576 = abc_2885_new_n1139
* NET  1577 = abc_2885_new_n1138
* NET  1578 = abc_2885_new_n1136
* NET  1579 = abc_2885_new_n1135
* NET  1580 = abc_2885_new_n1134
* NET  1581 = abc_2885_new_n1132
* NET  1582 = abc_2885_new_n1131
* NET  1583 = abc_2885_new_n1130
* NET  1584 = abc_2885_new_n1129
* NET  1585 = abc_2885_new_n1128
* NET  1586 = abc_2885_new_n1127
* NET  1587 = abc_2885_new_n1126
* NET  1588 = abc_2885_new_n1125
* NET  1589 = abc_2885_new_n1124
* NET  1590 = abc_2885_new_n1123
* NET  1591 = abc_2885_new_n1122
* NET  1592 = abc_2885_new_n1121
* NET  1593 = abc_2885_new_n1120
* NET  1594 = abc_2885_new_n1119
* NET  1595 = abc_2885_new_n1118
* NET  1596 = abc_2885_auto_rtlil_cc_2739_MuxGate_2884
* NET  1597 = abc_2885_auto_rtlil_cc_2739_MuxGate_2882
* NET  1598 = abc_2885_auto_rtlil_cc_2739_MuxGate_2880
* NET  1599 = abc_2885_auto_rtlil_cc_2739_MuxGate_2878
* NET  1600 = abc_2885_auto_rtlil_cc_2739_MuxGate_2876
* NET  1601 = abc_2885_auto_rtlil_cc_2739_MuxGate_2874
* NET  1602 = abc_2885_auto_rtlil_cc_2739_MuxGate_2872
* NET  1603 = abc_2885_auto_rtlil_cc_2739_MuxGate_2870
* NET  1604 = abc_2885_auto_rtlil_cc_2739_MuxGate_2868
* NET  1605 = abc_2885_auto_rtlil_cc_2739_MuxGate_2866
* NET  1606 = abc_2885_auto_rtlil_cc_2739_MuxGate_2864
* NET  1607 = abc_2885_auto_rtlil_cc_2739_MuxGate_2862
* NET  1608 = abc_2885_auto_rtlil_cc_2739_MuxGate_2860
* NET  1609 = abc_2885_auto_rtlil_cc_2739_MuxGate_2858
* NET  1610 = abc_2885_auto_rtlil_cc_2739_MuxGate_2856
* NET  1611 = abc_2885_auto_rtlil_cc_2739_MuxGate_2854
* NET  1612 = abc_2885_auto_rtlil_cc_2739_MuxGate_2852
* NET  1613 = abc_2885_auto_rtlil_cc_2739_MuxGate_2850
* NET  1614 = abc_2885_auto_rtlil_cc_2739_MuxGate_2848
* NET  1615 = abc_2885_auto_rtlil_cc_2739_MuxGate_2846
* NET  1616 = abc_2885_auto_rtlil_cc_2739_MuxGate_2844
* NET  1617 = abc_2885_auto_rtlil_cc_2739_MuxGate_2842
* NET  1618 = abc_2885_auto_rtlil_cc_2739_MuxGate_2840
* NET  1619 = abc_2885_auto_rtlil_cc_2739_MuxGate_2838
* NET  1620 = abc_2885_auto_rtlil_cc_2739_MuxGate_2836
* NET  1621 = abc_2885_auto_rtlil_cc_2739_MuxGate_2834
* NET  1622 = abc_2885_auto_rtlil_cc_2739_MuxGate_2832
* NET  1623 = abc_2885_auto_rtlil_cc_2739_MuxGate_2830
* NET  1624 = abc_2885_auto_rtlil_cc_2739_MuxGate_2828
* NET  1625 = abc_2885_auto_rtlil_cc_2739_MuxGate_2826
* NET  1626 = abc_2885_auto_rtlil_cc_2739_MuxGate_2824
* NET  1627 = abc_2885_auto_rtlil_cc_2739_MuxGate_2822
* NET  1628 = abc_2885_auto_rtlil_cc_2739_MuxGate_2820
* NET  1629 = abc_2885_auto_rtlil_cc_2739_MuxGate_2818
* NET  1630 = abc_2885_auto_rtlil_cc_2739_MuxGate_2816
* NET  1631 = abc_2885_auto_rtlil_cc_2739_MuxGate_2814
* NET  1632 = abc_2885_auto_rtlil_cc_2739_MuxGate_2812
* NET  1633 = abc_2885_auto_rtlil_cc_2739_MuxGate_2810
* NET  1634 = abc_2885_auto_rtlil_cc_2739_MuxGate_2808
* NET  1635 = abc_2885_auto_rtlil_cc_2739_MuxGate_2806
* NET  1636 = abc_2885_auto_rtlil_cc_2739_MuxGate_2804
* NET  1637 = abc_2885_auto_rtlil_cc_2739_MuxGate_2802
* NET  1638 = abc_2885_auto_rtlil_cc_2739_MuxGate_2800
* NET  1639 = abc_2885_auto_rtlil_cc_2739_MuxGate_2798
* NET  1640 = abc_2885_auto_rtlil_cc_2739_MuxGate_2796
* NET  1641 = abc_2885_auto_rtlil_cc_2739_MuxGate_2794
* NET  1642 = abc_2885_auto_rtlil_cc_2739_MuxGate_2792
* NET  1643 = abc_2885_auto_rtlil_cc_2739_MuxGate_2790
* NET  1644 = abc_2885_auto_rtlil_cc_2739_MuxGate_2788
* NET  1645 = abc_2885_auto_rtlil_cc_2739_MuxGate_2786
* NET  1646 = abc_2885_auto_rtlil_cc_2739_MuxGate_2784
* NET  1647 = abc_2885_auto_rtlil_cc_2739_MuxGate_2782
* NET  1648 = abc_2885_auto_rtlil_cc_2739_MuxGate_2780
* NET  1649 = abc_2885_auto_rtlil_cc_2739_MuxGate_2778
* NET  1650 = abc_2885_auto_rtlil_cc_2739_MuxGate_2776
* NET  1651 = abc_2885_auto_rtlil_cc_2739_MuxGate_2774
* NET  1652 = abc_2885_auto_rtlil_cc_2739_MuxGate_2772
* NET  1653 = abc_2885_auto_rtlil_cc_2739_MuxGate_2770
* NET  1654 = abc_2885_auto_rtlil_cc_2739_MuxGate_2768
* NET  1655 = abc_2885_auto_rtlil_cc_2739_MuxGate_2766
* NET  1656 = abc_2885_auto_rtlil_cc_2739_MuxGate_2764
* NET  1657 = abc_2885_auto_rtlil_cc_2739_MuxGate_2762
* NET  1658 = abc_2885_auto_rtlil_cc_2739_MuxGate_2760
* NET  1659 = abc_2885_auto_rtlil_cc_2739_MuxGate_2758
* NET  1660 = abc_2885_auto_rtlil_cc_2739_MuxGate_2756
* NET  1661 = abc_2885_auto_rtlil_cc_2739_MuxGate_2754
* NET  1662 = abc_2885_auto_rtlil_cc_2739_MuxGate_2752
* NET  1663 = abc_2885_auto_rtlil_cc_2739_MuxGate_2750
* NET  1664 = abc_2885_auto_rtlil_cc_2739_MuxGate_2748
* NET  1665 = abc_2885_auto_rtlil_cc_2739_MuxGate_2746
* NET  1666 = abc_2885_auto_rtlil_cc_2739_MuxGate_2744
* NET  1667 = abc_2885_auto_rtlil_cc_2739_MuxGate_2742
* NET  1668 = abc_2885_auto_rtlil_cc_2739_MuxGate_2740
* NET  1669 = abc_2885_auto_rtlil_cc_2739_MuxGate_2738
* NET  1670 = abc_2885_auto_rtlil_cc_2739_MuxGate_2736
* NET  1671 = abc_2885_auto_rtlil_cc_2739_MuxGate_2734
* NET  1672 = abc_2885_auto_rtlil_cc_2739_MuxGate_2732
* NET  1673 = abc_2885_auto_rtlil_cc_2739_MuxGate_2730
* NET  1674 = abc_2885_auto_rtlil_cc_2739_MuxGate_2728
* NET  1675 = abc_2885_auto_rtlil_cc_2739_MuxGate_2726
* NET  1676 = abc_2885_auto_rtlil_cc_2739_MuxGate_2724
* NET  1677 = abc_2885_auto_rtlil_cc_2739_MuxGate_2722
* NET  1678 = abc_2885_auto_rtlil_cc_2739_MuxGate_2720
* NET  1679 = abc_2885_auto_rtlil_cc_2739_MuxGate_2718
* NET  1680 = abc_2885_auto_rtlil_cc_2739_MuxGate_2716
* NET  1681 = abc_2885_auto_rtlil_cc_2739_MuxGate_2714
* NET  1682 = abc_2885_auto_rtlil_cc_2739_MuxGate_2712
* NET  1683 = abc_2885_auto_rtlil_cc_2739_MuxGate_2710
* NET  1684 = abc_2885_auto_rtlil_cc_2739_MuxGate_2708
* NET  1685 = abc_2885_auto_rtlil_cc_2739_MuxGate_2706
* NET  1686 = abc_2885_auto_rtlil_cc_2739_MuxGate_2704
* NET  1687 = abc_2885_auto_rtlil_cc_2739_MuxGate_2702
* NET  1688 = abc_2885_auto_rtlil_cc_2739_MuxGate_2700
* NET  1689 = abc_2885_auto_rtlil_cc_2739_MuxGate_2698
* NET  1690 = abc_2885_auto_rtlil_cc_2739_MuxGate_2696
* NET  1691 = abc_2885_auto_rtlil_cc_2739_MuxGate_2694
* NET  1692 = abc_2885_auto_rtlil_cc_2739_MuxGate_2692
* NET  1693 = abc_2885_auto_rtlil_cc_2739_MuxGate_2690
* NET  1694 = abc_2885_auto_rtlil_cc_2739_MuxGate_2688
* NET  1695 = abc_2885_auto_rtlil_cc_2739_MuxGate_2686
* NET  1696 = abc_2885_auto_rtlil_cc_2739_MuxGate_2684
* NET  1697 = abc_2885_auto_rtlil_cc_2739_MuxGate_2682
* NET  1698 = abc_2885_auto_rtlil_cc_2739_MuxGate_2680
* NET  1699 = abc_2885_auto_rtlil_cc_2739_MuxGate_2678
* NET  1700 = abc_2885_auto_rtlil_cc_2739_MuxGate_2676
* NET  1701 = abc_2885_auto_rtlil_cc_2739_MuxGate_2674
* NET  1702 = abc_2885_auto_rtlil_cc_2739_MuxGate_2672
* NET  1703 = abc_2885_auto_rtlil_cc_2739_MuxGate_2670
* NET  1704 = abc_2885_auto_rtlil_cc_2739_MuxGate_2668
* NET  1705 = abc_2885_auto_rtlil_cc_2739_MuxGate_2666
* NET  1706 = abc_2885_auto_rtlil_cc_2739_MuxGate_2664
* NET  1707 = abc_2885_auto_rtlil_cc_2739_MuxGate_2662
* NET  1708 = abc_2885_auto_rtlil_cc_2739_MuxGate_2660
* NET  1709 = abc_2885_auto_rtlil_cc_2739_MuxGate_2658
* NET  1710 = abc_2885_auto_rtlil_cc_2739_MuxGate_2656
* NET  1711 = abc_2885_auto_rtlil_cc_2739_MuxGate_2654
* NET  1712 = abc_2885_auto_rtlil_cc_2739_MuxGate_2652
* NET  1713 = abc_2885_auto_rtlil_cc_2739_MuxGate_2650
* NET  1714 = abc_2885_auto_rtlil_cc_2739_MuxGate_2648
* NET  1715 = abc_2885_auto_rtlil_cc_2739_MuxGate_2646
* NET  1716 = abc_2885_auto_rtlil_cc_2739_MuxGate_2644
* NET  1717 = abc_2885_auto_rtlil_cc_2739_MuxGate_2642
* NET  1718 = abc_2885_auto_rtlil_cc_2739_MuxGate_2640
* NET  1719 = abc_2885_auto_rtlil_cc_2739_MuxGate_2638
* NET  1720 = abc_2885_auto_rtlil_cc_2739_MuxGate_2636
* NET  1721 = abc_2885_auto_rtlil_cc_2739_MuxGate_2634
* NET  1722 = abc_2885_auto_rtlil_cc_2739_MuxGate_2632
* NET  1723 = abc_2885_auto_rtlil_cc_2739_MuxGate_2630
* NET  1724 = abc_2885_auto_rtlil_cc_2739_MuxGate_2628
* NET  1725 = abc_2885_auto_rtlil_cc_2739_MuxGate_2626
* NET  1726 = abc_2885_auto_rtlil_cc_2739_MuxGate_2624
* NET  1727 = abc_2885_auto_rtlil_cc_2739_MuxGate_2622
* NET  1728 = abc_2885_auto_rtlil_cc_2739_MuxGate_2620
* NET  1729 = abc_2885_auto_rtlil_cc_2739_MuxGate_2618
* NET  1730 = abc_2885_auto_rtlil_cc_2739_MuxGate_2616
* NET  1731 = abc_2885_auto_rtlil_cc_2739_MuxGate_2614
* NET  1732 = abc_2885_auto_rtlil_cc_2739_MuxGate_2612
* NET  1733 = abc_2885_auto_rtlil_cc_2739_MuxGate_2610
* NET  1734 = abc_2885_auto_rtlil_cc_2739_MuxGate_2608
* NET  1735 = abc_2885_auto_rtlil_cc_2739_MuxGate_2606
* NET  1736 = abc_2885_auto_rtlil_cc_2739_MuxGate_2604
* NET  1737 = abc_2885_auto_rtlil_cc_2739_MuxGate_2602
* NET  1738 = abc_2885_auto_rtlil_cc_2739_MuxGate_2600
* NET  1739 = abc_2885_auto_rtlil_cc_2739_MuxGate_2598
* NET  1740 = abc_2885_auto_rtlil_cc_2739_MuxGate_2596
* NET  1741 = abc_2885_auto_rtlil_cc_2739_MuxGate_2594
* NET  1742 = abc_2885_auto_rtlil_cc_2739_MuxGate_2592
* NET  1743 = abc_2885_auto_rtlil_cc_2739_MuxGate_2590
* NET  1744 = abc_2885_auto_rtlil_cc_2739_MuxGate_2588
* NET  1745 = abc_2885_auto_rtlil_cc_2739_MuxGate_2586
* NET  1746 = abc_2885_auto_rtlil_cc_2739_MuxGate_2584
* NET  1747 = abc_2885_auto_rtlil_cc_2739_MuxGate_2582
* NET  1748 = abc_2885_auto_rtlil_cc_2739_MuxGate_2580
* NET  1749 = abc_2885_auto_rtlil_cc_2739_MuxGate_2578
* NET  1750 = abc_2885_auto_rtlil_cc_2739_MuxGate_2576
* NET  1751 = abc_2885_auto_rtlil_cc_2739_MuxGate_2574
* NET  1752 = abc_2885_auto_rtlil_cc_2739_MuxGate_2572
* NET  1753 = abc_2885_auto_rtlil_cc_2739_MuxGate_2570
* NET  1754 = abc_2885_auto_rtlil_cc_2739_MuxGate_2568
* NET  1755 = abc_2885_auto_rtlil_cc_2739_MuxGate_2566
* NET  1756 = abc_2885_auto_rtlil_cc_2739_MuxGate_2564
* NET  1757 = abc_2885_auto_rtlil_cc_2739_MuxGate_2562
* NET  1758 = abc_2885_auto_rtlil_cc_2739_MuxGate_2560
* NET  1759 = abc_2885_auto_rtlil_cc_2739_MuxGate_2558
* NET  1760 = abc_2885_auto_rtlil_cc_2739_MuxGate_2556
* NET  1761 = abc_2885_auto_rtlil_cc_2739_MuxGate_2554
* NET  1762 = abc_2885_auto_rtlil_cc_2739_MuxGate_2552
* NET  1763 = abc_2885_auto_rtlil_cc_2739_MuxGate_2550
* NET  1764 = abc_2885_auto_rtlil_cc_2739_MuxGate_2548
* NET  1765 = abc_2885_auto_rtlil_cc_2739_MuxGate_2546
* NET  1766 = abc_2885_auto_rtlil_cc_2739_MuxGate_2544
* NET  1767 = abc_2885_auto_rtlil_cc_2739_MuxGate_2542
* NET  1768 = abc_2885_auto_rtlil_cc_2739_MuxGate_2540
* NET  1769 = abc_2885_auto_rtlil_cc_2739_MuxGate_2538
* NET  1770 = abc_2885_auto_rtlil_cc_2739_MuxGate_2536
* NET  1771 = abc_2885_auto_rtlil_cc_2739_MuxGate_2534
* NET  1772 = abc_2885_auto_rtlil_cc_2739_MuxGate_2532
* NET  1773 = abc_2885_auto_rtlil_cc_2739_MuxGate_2530
* NET  1774 = abc_2885_auto_rtlil_cc_2739_MuxGate_2528
* NET  1775 = abc_2885_auto_rtlil_cc_2739_MuxGate_2526
* NET  1776 = abc_2885_auto_rtlil_cc_2739_MuxGate_2524
* NET  1777 = abc_2885_auto_rtlil_cc_2739_MuxGate_2522
* NET  1778 = abc_2885_auto_rtlil_cc_2739_MuxGate_2520
* NET  1779 = abc_2885_auto_rtlil_cc_2739_MuxGate_2518
* NET  1780 = abc_2885_auto_rtlil_cc_2739_MuxGate_2516
* NET  1781 = abc_2885_auto_rtlil_cc_2739_MuxGate_2514
* NET  1782 = abc_2885_auto_rtlil_cc_2739_MuxGate_2512
* NET  1783 = abc_2885_auto_rtlil_cc_2739_MuxGate_2510
* NET  1784 = abc_2885_auto_rtlil_cc_2739_MuxGate_2508
* NET  1785 = abc_2885_auto_rtlil_cc_2739_MuxGate_2506
* NET  1786 = abc_2885_auto_rtlil_cc_2739_MuxGate_2504
* NET  1787 = abc_2885_auto_rtlil_cc_2739_MuxGate_2502
* NET  1788 = abc_2885_auto_rtlil_cc_2739_MuxGate_2500
* NET  1789 = abc_2885_auto_rtlil_cc_2739_MuxGate_2498
* NET  1790 = abc_2885_auto_rtlil_cc_2739_MuxGate_2496
* NET  1791 = abc_2885_auto_rtlil_cc_2739_MuxGate_2494
* NET  1792 = abc_2885_auto_rtlil_cc_2739_MuxGate_2492
* NET  1793 = abc_2885_auto_rtlil_cc_2739_MuxGate_2490
* NET  1794 = abc_2885_auto_rtlil_cc_2739_MuxGate_2488
* NET  1795 = abc_2885_auto_rtlil_cc_2739_MuxGate_2486
* NET  1796 = abc_2885_auto_rtlil_cc_2739_MuxGate_2484
* NET  1797 = abc_2885_auto_rtlil_cc_2739_MuxGate_2482
* NET  1798 = abc_2885_auto_rtlil_cc_2739_MuxGate_2480
* NET  1799 = abc_2885_auto_rtlil_cc_2739_MuxGate_2478
* NET  1800 = abc_2885_auto_rtlil_cc_2739_MuxGate_2476
* NET  1801 = abc_2885_auto_rtlil_cc_2739_MuxGate_2474
* NET  1802 = abc_2885_auto_rtlil_cc_2739_MuxGate_2472
* NET  1803 = abc_2885_auto_rtlil_cc_2739_MuxGate_2470
* NET  1804 = abc_2885_auto_rtlil_cc_2739_MuxGate_2468
* NET  1805 = abc_2885_auto_rtlil_cc_2739_MuxGate_2466
* NET  1806 = abc_2885_auto_rtlil_cc_2739_MuxGate_2464
* NET  1807 = abc_2885_auto_rtlil_cc_2739_MuxGate_2462
* NET  1808 = abc_2885_auto_rtlil_cc_2739_MuxGate_2460
* NET  1809 = abc_2885_auto_rtlil_cc_2739_MuxGate_2458
* NET  1810 = abc_2885_auto_rtlil_cc_2739_MuxGate_2456
* NET  1811 = abc_2885_auto_rtlil_cc_2739_MuxGate_2454
* NET  1812 = abc_2885_auto_rtlil_cc_2739_MuxGate_2452
* NET  1813 = abc_2885_auto_rtlil_cc_2739_MuxGate_2450
* NET  1814 = abc_2885_auto_rtlil_cc_2739_MuxGate_2448
* NET  1815 = abc_2885_auto_rtlil_cc_2739_MuxGate_2446
* NET  1816 = abc_2885_auto_rtlil_cc_2739_MuxGate_2444
* NET  1817 = abc_2885_auto_rtlil_cc_2739_MuxGate_2442
* NET  1818 = abc_2885_auto_rtlil_cc_2739_MuxGate_2440
* NET  1819 = abc_2885_auto_rtlil_cc_2739_MuxGate_2438
* NET  1820 = abc_2885_auto_rtlil_cc_2739_MuxGate_2436
* NET  1821 = abc_2885_auto_rtlil_cc_2739_MuxGate_2434
* NET  1822 = abc_2885_auto_rtlil_cc_2739_MuxGate_2432
* NET  1823 = abc_2885_auto_rtlil_cc_2739_MuxGate_2430
* NET  1824 = abc_2885_auto_rtlil_cc_2739_MuxGate_2428
* NET  1825 = abc_2885_auto_rtlil_cc_2739_MuxGate_2426
* NET  1826 = abc_2885_auto_rtlil_cc_2739_MuxGate_2424
* NET  1827 = abc_2885_auto_rtlil_cc_2739_MuxGate_2422
* NET  1828 = abc_2885_auto_rtlil_cc_2739_MuxGate_2420
* NET  1829 = abc_2885_auto_rtlil_cc_2739_MuxGate_2418
* NET  1830 = abc_2885_auto_rtlil_cc_2739_MuxGate_2416
* NET  1831 = abc_2885_auto_rtlil_cc_2739_MuxGate_2414
* NET  1832 = abc_2885_auto_rtlil_cc_2739_MuxGate_2412
* NET  1833 = abc_2885_auto_rtlil_cc_2739_MuxGate_2410
* NET  1834 = abc_2885_auto_rtlil_cc_2739_MuxGate_2408
* NET  1835 = abc_2885_auto_rtlil_cc_2739_MuxGate_2406
* NET  1836 = abc_2885_auto_rtlil_cc_2739_MuxGate_2404
* NET  1837 = abc_2885_auto_rtlil_cc_2739_MuxGate_2402
* NET  1838 = abc_2885_auto_rtlil_cc_2739_MuxGate_2400
* NET  1839 = abc_2885_auto_rtlil_cc_2739_MuxGate_2398
* NET  1840 = abc_2885_auto_rtlil_cc_2739_MuxGate_2396
* NET  1841 = abc_2885_auto_rtlil_cc_2739_MuxGate_2394
* NET  1842 = abc_2885_auto_rtlil_cc_2739_MuxGate_2392
* NET  1843 = abc_2885_auto_rtlil_cc_2739_MuxGate_2390
* NET  1844 = abc_2885_auto_rtlil_cc_2739_MuxGate_2388
* NET  1845 = abc_2885_auto_rtlil_cc_2739_MuxGate_2386
* NET  1846 = abc_2885_auto_rtlil_cc_2739_MuxGate_2384
* NET  1847 = abc_2885_auto_rtlil_cc_2739_MuxGate_2382
* NET  1848 = abc_2885_auto_rtlil_cc_2739_MuxGate_2380
* NET  1849 = abc_2885_auto_rtlil_cc_2739_MuxGate_2378
* NET  1850 = abc_2885_auto_rtlil_cc_2739_MuxGate_2376
* NET  1851 = abc_2885_auto_rtlil_cc_2739_MuxGate_2374
* NET  1852 = abc_2885_auto_rtlil_cc_2739_MuxGate_2372
* NET  1853 = abc_2885_auto_rtlil_cc_2739_MuxGate_2370
* NET  1854 = abc_2885_auto_rtlil_cc_2739_MuxGate_2368
* NET  1855 = abc_2885_auto_rtlil_cc_2739_MuxGate_2366
* NET  1856 = abc_2885_auto_rtlil_cc_2739_MuxGate_2364
* NET  1857 = abc_2885_auto_rtlil_cc_2739_MuxGate_2362
* NET  1858 = abc_2885_auto_rtlil_cc_2739_MuxGate_2360
* NET  1859 = abc_2885_auto_rtlil_cc_2739_MuxGate_2358
* NET  1860 = abc_2885_auto_rtlil_cc_2739_MuxGate_2356
* NET  1861 = abc_2885_auto_rtlil_cc_2739_MuxGate_2354
* NET  1862 = abc_2885_auto_rtlil_cc_2739_MuxGate_2352
* NET  1863 = abc_2885_auto_rtlil_cc_2739_MuxGate_2350
* NET  1864 = abc_2885_auto_rtlil_cc_2739_MuxGate_2348
* NET  1865 = abc_2885_auto_rtlil_cc_2739_MuxGate_2346
* NET  1866 = abc_2885_auto_rtlil_cc_2739_MuxGate_2344
* NET  1867 = abc_2885_auto_rtlil_cc_2739_MuxGate_2342
* NET  1868 = abc_2885_auto_rtlil_cc_2739_MuxGate_2340
* NET  1869 = abc_2885_auto_rtlil_cc_2739_MuxGate_2338
* NET  1870 = abc_2885_auto_rtlil_cc_2739_MuxGate_2336
* NET  1871 = abc_2885_auto_rtlil_cc_2739_MuxGate_2334
* NET  1872 = abc_2885_auto_rtlil_cc_2739_MuxGate_2332
* NET  1873 = abc_2885_auto_rtlil_cc_2739_MuxGate_2330
* NET  1874 = abc_2885_auto_rtlil_cc_2739_MuxGate_2328
* NET  1875 = abc_2885_auto_rtlil_cc_2739_MuxGate_2326
* NET  1876 = abc_2885_auto_rtlil_cc_2739_MuxGate_2324
* NET  1877 = abc_2885_auto_rtlil_cc_2739_MuxGate_2322
* NET  1878 = abc_2885_auto_rtlil_cc_2739_MuxGate_2320
* NET  1879 = abc_2885_auto_rtlil_cc_2739_MuxGate_2318
* NET  1880 = abc_2885_auto_rtlil_cc_2739_MuxGate_2316
* NET  1881 = abc_2885_auto_rtlil_cc_2739_MuxGate_2314
* NET  1882 = abc_2885_auto_rtlil_cc_2739_MuxGate_2312
* NET  1883 = abc_2885_auto_rtlil_cc_2739_MuxGate_2310

xsubckt_1339_dff_x1 1 0 1879 676 295 dff_x1
xsubckt_1338_dff_x1 1 0 1880 676 294 dff_x1
xsubckt_1337_dff_x1 1 0 1881 676 293 dff_x1
xsubckt_133_xor2_x0 1 0 396 62 61 xor2_x0
xsubckt_744_and4_x1 1 0 1142 1585 99 702 675 and4_x1
xsubckt_962_nand2_x0 1 0 975 452 703 nand2_x0
xsubckt_1130_and2_x1 1 0 846 494 703 and2_x1
xsubckt_1135_and21nor_x0 1 0 842 79 1583 843 and21nor_x0
xsubckt_396_and2_x1 1 0 1408 558 703 and2_x1
xsubckt_79_xor2_x0 1 0 342 197 196 xor2_x0
xsubckt_779_and4_x1 1 0 1115 1585 117 702 675 and4_x1
xsubckt_782_nand2_x0 1 0 1740 1113 1116 nand2_x0
xsubckt_872_nand2_x0 1 0 1719 1044 1046 nand2_x0
xsubckt_129_xor2_x0 1 0 392 53 52 xor2_x0
xsubckt_692_nand2_x0 1 0 1182 1583 219 nand2_x0
xsubckt_727_nand4_x0 1 0 1155 1585 91 702 675 nand4_x0
xsubckt_753_and2_x1 1 0 1135 652 703 and2_x1
xsubckt_1079_and21nor_x0 1 0 885 64 1583 886 and21nor_x0
xsubckt_822_and21nor_x0 1 0 1082 252 1583 1083 and21nor_x0
xsubckt_457_nand4_x0 1 0 1362 1585 359 702 675 nand4_x0
xsubckt_334_nand2_x0 1 0 1845 1456 1458 nand2_x0
xsubckt_244_nand2_x0 1 0 1525 1583 103 nand2_x0
xsubckt_800_nand4_x0 1 0 1099 1585 128 702 675 nand4_x0
xsubckt_1065_nand2_x0 1 0 896 1583 61 nand2_x0
xsubckt_618_and21nor_x0 1 0 1238 199 1583 1239 and21nor_x0
xsubckt_173_and2_x1 1 0 1579 501 703 and2_x1
xsubckt_710_nand4_x0 1 0 1168 1585 418 702 675 nand4_x0
xsubckt_530_nand4_x0 1 0 1306 1585 376 702 675 nand4_x0
xsubckt_365_and21nor_x0 1 0 1432 134 1583 1433 and21nor_x0
xsubckt_169_and2_x1 1 0 1582 500 703 and2_x1
xsubckt_277_nand4_x0 1 0 1500 1585 317 702 675 nand4_x0
xsubckt_565_and2_x1 1 0 1279 603 703 and2_x1
xsubckt_1007_nand2_x0 1 0 1687 941 943 nand2_x0
xsubckt_1171_nand4_x0 1 0 815 1585 66 702 675 nand4_x0
xsubckt_1334_and2_x1 1 0 1596 705 265 and2_x1
xsubckt_577_nand4_x0 1 0 1270 1585 387 702 675 nand4_x0
xsubckt_1081_nand4_x0 1 0 884 1585 20 702 675 nand4_x0
xsubckt_1149_nor2_x0 1 0 831 832 833 nor2_x0
xsubckt_1530_dff_x1 1 0 1688 676 232 dff_x1
xsubckt_434_and2_x1 1 0 1379 569 703 and2_x1
xsubckt_818_and21nor_x0 1 0 1085 251 1583 1086 and21nor_x0
xsubckt_856_and4_x1 1 0 1056 1585 158 702 675 and4_x1
xsubckt_1102_and4_x1 1 0 868 1585 31 702 675 and4_x1
xsubckt_1535_dff_x1 1 0 1683 676 243 dff_x1
xsubckt_1534_dff_x1 1 0 1684 676 241 dff_x1
xsubckt_1533_dff_x1 1 0 1685 676 239 dff_x1
xsubckt_1532_dff_x1 1 0 1686 676 237 dff_x1
xsubckt_1531_dff_x1 1 0 1687 676 235 dff_x1
xsubckt_368_and4_x1 1 0 1430 1585 338 702 675 and4_x1
xsubckt_64_xor2_x0 1 0 327 164 163 xor2_x0
xsubckt_830_and2_x1 1 0 1076 671 703 and2_x1
xsubckt_1217_nand2_x0 1 0 1638 780 783 nand2_x0
xsubckt_1539_dff_x1 1 0 1679 676 252 dff_x1
xsubckt_1538_dff_x1 1 0 1680 676 250 dff_x1
xsubckt_1537_dff_x1 1 0 1681 676 248 dff_x1
xsubckt_1536_dff_x1 1 0 1682 676 246 dff_x1
xsubckt_1492_dff_x1 1 0 1726 676 149 dff_x1
xsubckt_1491_dff_x1 1 0 1727 676 147 dff_x1
xsubckt_1490_dff_x1 1 0 1728 676 143 dff_x1
xsubckt_519_nand4_x0 1 0 1314 1585 373 702 675 nand4_x0
xsubckt_394_nand2_x0 1 0 1410 1583 141 nand2_x0
xsubckt_153_xor2_x0 1 0 416 67 56 xor2_x0
xsubckt_697_nand4_x0 1 0 1178 1585 415 702 675 nand4_x0
xsubckt_1023_nand4_x0 1 0 928 1585 243 702 675 nand4_x0
xsubckt_1037_nand2_x0 1 0 1680 918 921 nand2_x0
xsubckt_1127_nand2_x0 1 0 1659 849 851 nand2_x0
xsubckt_1498_dff_x1 1 0 1720 676 162 dff_x1
xsubckt_1497_dff_x1 1 0 1721 676 160 dff_x1
xsubckt_1496_dff_x1 1 0 1722 676 158 dff_x1
xsubckt_1495_dff_x1 1 0 1723 676 155 dff_x1
xsubckt_1494_dff_x1 1 0 1724 676 153 dff_x1
xsubckt_1493_dff_x1 1 0 1725 676 151 dff_x1
xsubckt_339_nand4_x0 1 0 1452 1585 331 702 675 nand4_x0
xsubckt_114_xor2_x0 1 0 377 20 19 xor2_x0
xsubckt_99_xor2_x0 1 0 362 241 240 xor2_x0
xsubckt_216_nand2_x0 1 0 1872 1547 1549 nand2_x0
xsubckt_665_and21nor_x0 1 0 1202 212 1583 1203 and21nor_x0
xsubckt_860_nand4_x0 1 0 1053 1585 160 702 675 nand4_x0
xsubckt_1200_nand2_x0 1 0 1642 793 796 nand2_x0
xsubckt_1499_dff_x1 1 0 1719 676 164 dff_x1
xsubckt_516_nand2_x0 1 0 1802 1317 1320 nand2_x0
xsubckt_149_xor2_x0 1 0 412 233 222 xor2_x0
xsubckt_250_and2_x1 1 0 1520 521 703 and2_x1
xsubckt_921_and21nor_x0 1 0 1006 24 1583 1007 and21nor_x0
xsubckt_1107_and2_x1 1 0 864 489 703 and2_x1
xsubckt_1110_nand2_x0 1 0 862 1583 73 nand2_x0
xsubckt_422_nor2_x0 1 0 1388 1389 1390 nor2_x0
xsubckt_668_and4_x1 1 0 1200 1585 408 702 675 and4_x1
xsubckt_1020_nand2_x0 1 0 1684 931 934 nand2_x0
xsubckt_1247_nand2_x0 1 0 757 1583 145 nand2_x0
xsubckt_322_nand4_x0 1 0 1465 1585 327 702 675 nand4_x0
xsubckt_642_and2_x1 1 0 1220 623 703 and2_x1
xsubckt_1181_and21nor_x0 1 0 807 167 1583 808 and21nor_x0
xsubckt_193_and2_x1 1 0 1564 507 703 and2_x1
xsubckt_677_and2_x1 1 0 1193 632 703 and2_x1
xsubckt_726_nand2_x0 1 0 1753 1156 1158 nand2_x0
xsubckt_890_nand4_x0 1 0 1030 1585 175 702 675 nand4_x0
xsubckt_1306_and4_x1 1 0 721 289 285 286 290 and4_x1
xsubckt_622_nand4_x0 1 0 1235 1585 397 702 675 nand4_x0
xsubckt_4_inv_x0 1 0 268 700 inv_x0
xsubckt_3_inv_x0 1 0 266 701 inv_x0
xsubckt_2_inv_x0 1 0 265 702 inv_x0
xsubckt_1_inv_x0 1 0 675 703 inv_x0
xsubckt_0_inv_x0 1 0 290 704 inv_x0
xsubckt_849_nor2_x0 1 0 1061 1062 1063 nor2_x0
xsubckt_1321_nexor2_x0 1 0 712 696 1603 nexor2_x0
xsubckt_1312_nexor2_x0 1 0 717 692 1607 nexor2_x0
xsubckt_456_nand2_x0 1 0 1816 1363 1365 nand2_x0
xsubckt_9_inv_x0 1 0 274 695 inv_x0
xsubckt_8_inv_x0 1 0 273 696 inv_x0
xsubckt_7_inv_x0 1 0 271 697 inv_x0
xsubckt_6_inv_x0 1 0 270 698 inv_x0
xsubckt_5_inv_x0 1 0 269 699 inv_x0
xsubckt_189_and2_x1 1 0 1567 505 703 and2_x1
xsubckt_1050_nand2_x0 1 0 1677 908 910 nand2_x0
xsubckt_1187_nand2_x0 1 0 803 1583 189 nand2_x0
xsubckt_366_nand2_x0 1 0 1837 1432 1434 nand2_x0
xsubckt_276_nand2_x0 1 0 1858 1501 1503 nand2_x0
xsubckt_846_nand2_x0 1 0 1064 1583 5 nand2_x0
xsubckt_942_and2_x1 1 0 990 446 703 and2_x1
xsubckt_1214_and4_x1 1 0 782 1585 144 702 675 and4_x1
xsubckt_454_and2_x1 1 0 1364 575 703 and2_x1
xsubckt_399_nand4_x0 1 0 1406 1585 345 702 675 nand4_x0
xsubckt_172_nand4_x0 1 0 1580 1585 292 702 675 nand4_x0
xsubckt_666_nand2_x0 1 0 1767 1202 1204 nand2_x0
xsubckt_1343_dff_x1 1 0 1875 676 299 dff_x1
xsubckt_1342_dff_x1 1 0 1876 676 298 dff_x1
xsubckt_1341_dff_x1 1 0 1877 676 297 dff_x1
xsubckt_1340_dff_x1 1 0 1878 676 296 dff_x1
xsubckt_1333_nexor2_x0 1 0 706 701 1597 nexor2_x0
xsubckt_576_nand2_x0 1 0 1788 1271 1274 nand2_x0
xsubckt_263_and21nor_x0 1 0 1510 107 1583 1511 and21nor_x0
xsubckt_1205_nand4_x0 1 0 789 1585 100 702 675 nand4_x0
xsubckt_1223_and2_x1 1 0 775 440 703 and2_x1
xsubckt_1349_dff_x1 1 0 1869 676 305 dff_x1
xsubckt_1348_dff_x1 1 0 1870 676 304 dff_x1
xsubckt_1347_dff_x1 1 0 1871 676 303 dff_x1
xsubckt_1346_dff_x1 1 0 1872 676 302 dff_x1
xsubckt_1345_dff_x1 1 0 1873 676 301 dff_x1
xsubckt_1344_dff_x1 1 0 1874 676 300 dff_x1
xsubckt_323_and2_x1 1 0 1464 540 703 and2_x1
xsubckt_84_xor2_x0 1 0 347 208 207 xor2_x0
xsubckt_45_xor2_x0 1 0 308 121 120 xor2_x0
xsubckt_215_and21nor_x0 1 0 1547 95 1583 1548 and21nor_x0
xsubckt_222_and4_x1 1 0 1542 1585 304 702 675 and4_x1
xsubckt_308_nand2_x0 1 0 1476 1583 119 nand2_x0
xsubckt_1025_nand4_x0 1 0 927 1585 246 702 675 nand4_x0
xsubckt_1039_nand2_x0 1 0 916 471 703 nand2_x0
xsubckt_1080_nand2_x0 1 0 1670 885 887 nand2_x0
xsubckt_1115_nand4_x0 1 0 858 1585 38 702 675 nand4_x0
xsubckt_1219_and2_x1 1 0 778 429 703 and2_x1
xsubckt_1258_and2_x1 1 0 750 289 290 and2_x1
xsubckt_134_xor2_x0 1 0 397 64 63 xor2_x0
xsubckt_716_and21nor_x0 1 0 1163 225 1583 1164 and21nor_x0
xsubckt_518_nand2_x0 1 0 1315 591 703 nand2_x0
xsubckt_270_and2_x1 1 0 1505 526 703 and2_x1
xsubckt_315_and21nor_x0 1 0 1470 120 1583 1471 and21nor_x0
xsubckt_319_and2_x1 1 0 1467 538 703 and2_x1
xsubckt_682_nand4_x0 1 0 1189 1585 411 702 675 nand4_x0
xsubckt_696_nand2_x0 1 0 1760 1179 1182 nand2_x0
xsubckt_786_nand2_x0 1 0 1739 1110 1112 nand2_x0
xsubckt_1327_nexor2_x0 1 0 709 698 1600 nexor2_x0
xsubckt_463_and21nor_x0 1 0 1357 160 1583 1358 and21nor_x0
xsubckt_428_nand2_x0 1 0 1384 1583 151 nand2_x0
xsubckt_10_inv_x0 1 0 275 694 inv_x0
xsubckt_11_inv_x0 1 0 276 693 inv_x0
xsubckt_12_inv_x0 1 0 277 692 inv_x0
xsubckt_13_inv_x0 1 0 281 691 inv_x0
xsubckt_14_inv_x0 1 0 282 690 inv_x0
xsubckt_201_nand2_x0 1 0 1558 1583 92 nand2_x0
xsubckt_715_and2_x1 1 0 1164 642 703 and2_x1
xsubckt_789_and2_x1 1 0 1107 660 703 and2_x1
xsubckt_926_nor2_x0 1 0 1002 1003 1004 nor2_x0
xsubckt_1022_nand2_x0 1 0 929 467 703 nand2_x0
xsubckt_1250_nor2_x0 1 0 754 755 756 nor2_x0
xsubckt_522_and4_x1 1 0 1312 1585 374 702 675 and4_x1
xsubckt_338_nand2_x0 1 0 1844 1453 1455 nand2_x0
xsubckt_15_inv_x0 1 0 280 689 inv_x0
xsubckt_16_inv_x0 1 0 283 688 inv_x0
xsubckt_17_inv_x0 1 0 284 687 inv_x0
xsubckt_18_inv_x0 1 0 286 686 inv_x0
xsubckt_19_inv_x0 1 0 285 685 inv_x0
xsubckt_227_and2_x1 1 0 1538 515 703 and2_x1
xsubckt_259_and21nor_x0 1 0 1513 106 1583 1514 and21nor_x0
xsubckt_266_and2_x1 1 0 1508 525 703 and2_x1
xsubckt_804_nand4_x0 1 0 1096 1585 130 702 675 nand4_x0
xsubckt_1035_and2_x1 1 0 919 470 703 and2_x1
xsubckt_1074_and2_x1 1 0 889 480 703 and2_x1
xsubckt_1232_and21nor_x0 1 0 768 45 1583 769 and21nor_x0
xsubckt_248_nand2_x0 1 0 1522 1583 104 nand2_x0
xsubckt_311_nor2_x0 1 0 1473 1474 1475 nor2_x0
xsubckt_714_nand4_x0 1 0 1165 1585 84 702 675 nand4_x0
xsubckt_992_and4_x1 1 0 952 1585 228 702 675 and4_x1
xsubckt_624_nand4_x0 1 0 1234 1585 398 702 675 nand4_x0
xsubckt_534_nand4_x0 1 0 1303 1585 377 702 675 nand4_x0
xsubckt_531_and2_x1 1 0 1305 594 703 and2_x1
xsubckt_321_nand2_x0 1 0 1848 1466 1469 nand2_x0
xsubckt_1300_and2_x1 1 0 724 282 281 and2_x1
xsubckt_781_nor2_x0 1 0 1113 1114 1115 nor2_x0
xsubckt_621_nand2_x0 1 0 1236 618 703 nand2_x0
xsubckt_527_and2_x1 1 0 1308 593 703 and2_x1
xsubckt_459_and21nor_x0 1 0 1360 159 1583 1361 and21nor_x0
xsubckt_400_and2_x1 1 0 1405 559 703 and2_x1
xsubckt_293_nor2_x0 1 0 1487 1488 1489 nor2_x0
xsubckt_1085_nand4_x0 1 0 881 1585 22 702 675 nand4_x0
xsubckt_1272_nexor2_x0 1 0 743 680 1621 nexor2_x0
xsubckt_795_nand3_x0 1 0 1737 1103 1104 1105 nand3_x0
xsubckt_997_and2_x1 1 0 948 460 703 and2_x1
xsubckt_1031_and21nor_x0 1 0 922 52 1583 923 and21nor_x0
xsubckt_1263_nexor2_x0 1 0 748 677 1625 nexor2_x0
xsubckt_1269_and4_x1 1 0 743 745 750 1583 263 and4_x1
xsubckt_1542_dff_x1 1 0 1676 676 5 dff_x1
xsubckt_1541_dff_x1 1 0 1677 676 3 dff_x1
xsubckt_1540_dff_x1 1 0 1678 676 254 dff_x1
xsubckt_30_xor2_x0 1 0 293 88 87 xor2_x0
xsubckt_654_nand4_x0 1 0 1211 1585 405 702 675 nand4_x0
xsubckt_870_and2_x1 1 0 1045 427 703 and2_x1
xsubckt_958_and2_x1 1 0 978 450 703 and2_x1
xsubckt_1548_dff_x1 1 0 1670 676 18 dff_x1
xsubckt_1547_dff_x1 1 0 1671 676 16 dff_x1
xsubckt_1546_dff_x1 1 0 1672 676 14 dff_x1
xsubckt_1545_dff_x1 1 0 1673 676 11 dff_x1
xsubckt_1544_dff_x1 1 0 1674 676 9 dff_x1
xsubckt_1543_dff_x1 1 0 1675 676 7 dff_x1
xsubckt_1293_nexor2_x0 1 0 730 687 1613 nexor2_x0
xsubckt_382_and2_x1 1 0 1419 555 703 and2_x1
xsubckt_65_xor2_x0 1 0 328 166 165 xor2_x0
xsubckt_866_and2_x1 1 0 1048 426 703 and2_x1
xsubckt_1019_nor2_x0 1 0 931 932 933 nor2_x0
xsubckt_1138_and4_x1 1 0 840 1585 49 702 675 and4_x1
xsubckt_1549_dff_x1 1 0 1669 676 20 dff_x1
xsubckt_593_nor2_x0 1 0 1257 1258 1259 nor2_x0
xsubckt_398_nand2_x0 1 0 1830 1407 1410 nand2_x0
xsubckt_154_xor2_x0 1 0 417 145 78 xor2_x0
xsubckt_115_xor2_x0 1 0 378 22 21 xor2_x0
xsubckt_171_nand2_x0 1 0 1883 1581 1584 nand2_x0
xsubckt_1112_and2_x1 1 0 860 490 703 and2_x1
xsubckt_515_nor2_x0 1 0 1317 1318 1319 nor2_x0
xsubckt_378_and2_x1 1 0 1422 554 703 and2_x1
xsubckt_684_nand4_x0 1 0 1188 1585 412 702 675 nand4_x0
xsubckt_774_nand4_x0 1 0 1119 1585 115 702 675 nand4_x0
xsubckt_1075_and21nor_x0 1 0 888 63 1583 889 and21nor_x0
xsubckt_1114_nand2_x0 1 0 1662 859 862 nand2_x0
xsubckt_1204_nand2_x0 1 0 1641 790 792 nand2_x0
xsubckt_1257_nexor2_x0 1 0 1583 704 1627 nexor2_x0
xsubckt_1027_and21nor_x0 1 0 925 51 1583 926 and21nor_x0
xsubckt_1094_and2_x1 1 0 874 486 703 and2_x1
xsubckt_614_and21nor_x0 1 0 1241 198 1583 1242 and21nor_x0
xsubckt_503_nand2_x0 1 0 1327 1583 171 nand2_x0
xsubckt_497_nor2_x0 1 0 1331 1332 1333 nor2_x0
xsubckt_370_nor2_x0 1 0 1428 1429 1430 nor2_x0
xsubckt_681_nand2_x0 1 0 1190 633 703 nand2_x0
xsubckt_1278_nexor2_x0 1 0 739 683 1619 nexor2_x0
xsubckt_1307_and4_x1 1 0 720 284 283 280 279 and4_x1
xsubckt_551_and2_x1 1 0 1290 600 703 and2_x1
xsubckt_361_and21nor_x0 1 0 1435 132 1583 1436 and21nor_x0
xsubckt_959_and21nor_x0 1 0 977 33 1583 978 and21nor_x0
xsubckt_1234_nand2_x0 1 0 767 1583 56 nand2_x0
xsubckt_1299_nexor2_x0 1 0 726 690 1611 nexor2_x0
xsubckt_713_nand2_x0 1 0 1756 1166 1168 nand2_x0
xsubckt_803_nand2_x0 1 0 1735 1097 1099 nand2_x0
xsubckt_862_and21nor_x0 1 0 1051 8 1583 1052 and21nor_x0
xsubckt_1040_nand4_x0 1 0 915 1585 252 702 675 nand4_x0
xsubckt_547_and2_x1 1 0 1293 599 703 and2_x1
xsubckt_1177_nand4_x0 1 0 810 1585 69 702 675 nand4_x0
xsubckt_533_nand2_x0 1 0 1798 1304 1306 nand2_x0
xsubckt_413_and21nor_x0 1 0 1395 147 1583 1396 and21nor_x0
xsubckt_176_nand4_x0 1 0 1577 1585 293 702 675 nand4_x0
xsubckt_670_nor2_x0 1 0 1198 1199 1200 nor2_x0
xsubckt_814_and21nor_x0 1 0 1088 250 1583 1089 and21nor_x0
xsubckt_1350_dff_x1 1 0 1868 676 306 dff_x1
xsubckt_561_and21nor_x0 1 0 1282 185 1583 1283 and21nor_x0
xsubckt_50_xor2_x0 1 0 313 132 131 xor2_x0
xsubckt_838_and4_x1 1 0 1070 1585 149 702 675 and4_x1
xsubckt_923_nand2_x0 1 0 1005 1583 25 nand2_x0
xsubckt_1174_nand2_x0 1 0 1648 813 815 nand2_x0
xsubckt_1209_nand4_x0 1 0 786 1585 122 702 675 nand4_x0
xsubckt_1356_dff_x1 1 0 1862 676 312 dff_x1
xsubckt_1355_dff_x1 1 0 1863 676 311 dff_x1
xsubckt_1354_dff_x1 1 0 1864 676 310 dff_x1
xsubckt_1353_dff_x1 1 0 1865 676 309 dff_x1
xsubckt_1352_dff_x1 1 0 1866 676 308 dff_x1
xsubckt_1351_dff_x1 1 0 1867 676 307 dff_x1
xsubckt_476_nand4_x0 1 0 1347 1585 363 702 675 nand4_x0
xsubckt_100_xor2_x0 1 0 363 243 242 xor2_x0
xsubckt_85_xor2_x0 1 0 348 210 209 xor2_x0
xsubckt_46_xor2_x0 1 0 309 124 123 xor2_x0
xsubckt_743_nand2_x0 1 0 1143 1583 232 nand2_x0
xsubckt_758_and21nor_x0 1 0 1131 236 1583 1132 and21nor_x0
xsubckt_1084_nand2_x0 1 0 1669 882 884 nand2_x0
xsubckt_1197_and4_x1 1 0 795 1585 80 702 675 and4_x1
xsubckt_1359_dff_x1 1 0 1859 676 315 dff_x1
xsubckt_1358_dff_x1 1 0 1860 676 314 dff_x1
xsubckt_1357_dff_x1 1 0 1861 676 313 dff_x1
xsubckt_135_xor2_x0 1 0 398 66 65 xor2_x0
xsubckt_653_nand2_x0 1 0 1770 1212 1215 nand2_x0
xsubckt_1029_nand4_x0 1 0 924 1585 248 702 675 nand4_x0
xsubckt_563_nand2_x0 1 0 1281 1583 186 nand2_x0
xsubckt_693_and4_x1 1 0 1181 1585 414 702 675 and4_x1
xsubckt_720_and2_x1 1 0 1160 643 703 and2_x1
xsubckt_1126_and21nor_x0 1 0 849 76 1583 850 and21nor_x0
xsubckt_508_nand4_x0 1 0 1323 1585 371 702 675 nand4_x0
xsubckt_473_nand2_x0 1 0 1812 1350 1353 nand2_x0
xsubckt_21_inv_x0 1 0 260 683 inv_x0
xsubckt_20_inv_x0 1 0 287 684 inv_x0
xsubckt_232_and2_x1 1 0 1534 516 703 and2_x1
xsubckt_953_nand2_x0 1 0 982 1583 32 nand2_x0
xsubckt_1001_and2_x1 1 0 945 461 703 and2_x1
xsubckt_1012_nand4_x0 1 0 937 1585 239 702 675 nand4_x0
xsubckt_26_inv_x0 1 0 267 678 inv_x0
xsubckt_25_inv_x0 1 0 263 679 inv_x0
xsubckt_24_inv_x0 1 0 262 680 inv_x0
xsubckt_23_inv_x0 1 0 261 681 inv_x0
xsubckt_22_inv_x0 1 0 259 682 inv_x0
xsubckt_773_nand2_x0 1 0 1742 1120 1123 nand2_x0
xsubckt_808_nand4_x0 1 0 1093 1585 132 702 675 nand4_x0
xsubckt_863_nand2_x0 1 0 1721 1051 1053 nand2_x0
xsubckt_27_inv_x0 1 0 278 677 inv_x0
xsubckt_896_nand4_x0 1 0 1025 1585 177 702 675 nand4_x0
xsubckt_470_and4_x1 1 0 1352 1585 362 702 675 and4_x1
xsubckt_415_nand2_x0 1 0 1394 1583 148 nand2_x0
xsubckt_698_and2_x1 1 0 1177 637 703 and2_x1
xsubckt_1146_nand2_x0 1 0 834 1583 82 nand2_x0
xsubckt_1222_nand4_x0 1 0 776 1585 189 702 675 nand4_x0
xsubckt_1314_and3_x1 1 0 714 715 718 1583 and3_x1
xsubckt_538_nand4_x0 1 0 1300 1585 378 702 675 nand4_x0
xsubckt_325_nand2_x0 1 0 1847 1463 1465 nand2_x0
xsubckt_915_and4_x1 1 0 1011 1585 188 702 675 and4_x1
xsubckt_704_nor2_x0 1 0 1172 1173 1174 nor2_x0
xsubckt_893_nand2_x0 1 0 1714 1028 1030 nand2_x0
xsubckt_928_nand4_x0 1 0 1001 1585 195 702 675 nand4_x0
xsubckt_1179_nand4_x0 1 0 809 1585 71 702 675 nand4_x0
xsubckt_300_and4_x1 1 0 1482 1585 322 702 675 and4_x1
xsubckt_1063_nor2_x0 1 0 897 898 899 nor2_x0
xsubckt_1089_nand4_x0 1 0 878 1585 25 702 675 nand4_x0
xsubckt_568_nand4_x0 1 0 1277 1585 385 702 675 nand4_x0
xsubckt_355_nand2_x0 1 0 1440 1583 131 nand2_x0
xsubckt_31_xor2_x0 1 0 294 91 90 xor2_x0
xsubckt_70_xor2_x0 1 0 333 177 176 xor2_x0
xsubckt_770_and4_x1 1 0 1122 1585 113 702 675 and4_x1
xsubckt_1173_and21nor_x0 1 0 813 144 1583 814 and21nor_x0
xsubckt_1176_nand2_x0 1 0 811 573 703 nand2_x0
xsubckt_1244_and2_x1 1 0 759 495 703 and2_x1
xsubckt_1252_nand4_x0 1 0 753 1585 145 702 675 nand4_x0
xsubckt_1555_dff_x1 1 0 1663 676 33 dff_x1
xsubckt_1554_dff_x1 1 0 1664 676 31 dff_x1
xsubckt_1553_dff_x1 1 0 1665 676 29 dff_x1
xsubckt_1552_dff_x1 1 0 1666 676 27 dff_x1
xsubckt_1551_dff_x1 1 0 1667 676 25 dff_x1
xsubckt_1550_dff_x1 1 0 1668 676 22 dff_x1
xsubckt_478_nand4_x0 1 0 1346 1585 364 702 675 nand4_x0
xsubckt_120_xor2_x0 1 0 383 33 32 xor2_x0
xsubckt_66_xor2_x0 1 0 329 169 168 xor2_x0
xsubckt_211_and21nor_x0 1 0 1550 94 1583 1551 and21nor_x0
xsubckt_282_and4_x1 1 0 1496 1585 318 702 675 and4_x1
xsubckt_1559_dff_x1 1 0 1659 676 42 dff_x1
xsubckt_1558_dff_x1 1 0 1660 676 40 dff_x1
xsubckt_1557_dff_x1 1 0 1661 676 38 dff_x1
xsubckt_1556_dff_x1 1 0 1662 676 36 dff_x1
xsubckt_344_and2_x1 1 0 1448 545 703 and2_x1
xsubckt_155_xor2_x0 1 0 418 257 256 xor2_x0
xsubckt_175_nand2_x0 1 0 1882 1578 1580 nand2_x0
xsubckt_305_and2_x1 1 0 1478 535 703 and2_x1
xsubckt_712_and21nor_x0 1 0 1166 224 1583 1167 and21nor_x0
xsubckt_731_nand4_x0 1 0 1152 1585 93 702 675 nand4_x0
xsubckt_1152_and2_x1 1 0 829 506 703 and2_x1
xsubckt_600_and4_x1 1 0 1252 1585 392 702 675 and4_x1
xsubckt_116_xor2_x0 1 0 379 25 24 xor2_x0
xsubckt_740_and2_x1 1 0 1145 648 703 and2_x1
xsubckt_1208_nand2_x0 1 0 1640 787 789 nand2_x0
xsubckt_475_nand2_x0 1 0 1348 580 703 nand2_x0
xsubckt_461_nand4_x0 1 0 1359 1585 360 702 675 nand4_x0
xsubckt_385_nand2_x0 1 0 1417 1583 139 nand2_x0
xsubckt_656_and21nor_x0 1 0 1209 209 1583 1210 and21nor_x0
xsubckt_736_and2_x1 1 0 1148 647 703 and2_x1
xsubckt_775_and2_x1 1 0 1118 657 703 and2_x1
xsubckt_1028_nand2_x0 1 0 1682 925 927 nand2_x0
xsubckt_1118_nand2_x0 1 0 1661 856 858 nand2_x0
xsubckt_1148_and2_x1 1 0 832 499 703 and2_x1
xsubckt_1192_nand4_x0 1 0 799 1585 77 702 675 nand4_x0
xsubckt_582_and4_x1 1 0 1266 1585 388 702 675 and4_x1
xsubckt_255_and21nor_x0 1 0 1516 105 1583 1517 and21nor_x0
xsubckt_287_and2_x1 1 0 1492 531 703 and2_x1
xsubckt_851_nand4_x0 1 0 1060 1585 155 702 675 nand4_x0
xsubckt_605_and2_x1 1 0 1248 613 703 and2_x1
xsubckt_507_nand2_x0 1 0 1804 1324 1327 nand2_x0
xsubckt_504_and4_x1 1 0 1326 1585 370 702 675 and4_x1
xsubckt_207_and21nor_x0 1 0 1553 93 1583 1554 and21nor_x0
xsubckt_898_nand4_x0 1 0 1024 1585 180 702 675 nand4_x0
xsubckt_912_and21nor_x0 1 0 1013 21 1583 1014 and21nor_x0
xsubckt_1101_nand2_x0 1 0 869 1583 71 nand2_x0
xsubckt_403_nand4_x0 1 0 1403 1585 346 702 675 nand4_x0
xsubckt_708_and21nor_x0 1 0 1169 223 1583 1170 and21nor_x0
xsubckt_1011_nand2_x0 1 0 1686 938 940 nand2_x0
xsubckt_1140_nor2_x0 1 0 838 839 840 nor2_x0
xsubckt_1238_nand2_x0 1 0 764 1583 67 nand2_x0
xsubckt_1308_and4_x1 1 0 719 720 721 724 745 and4_x1
xsubckt_313_nand4_x0 1 0 1472 1585 325 702 675 nand4_x0
xsubckt_807_nand2_x0 1 0 1734 1094 1096 nand2_x0
xsubckt_1259_xor2_x0 1 0 289 290 749 xor2_x0
xsubckt_627_nand2_x0 1 0 1776 1232 1234 nand2_x0
xsubckt_587_and2_x1 1 0 1262 609 703 and2_x1
xsubckt_455_and21nor_x0 1 0 1363 158 1583 1364 and21nor_x0
xsubckt_717_nand2_x0 1 0 1755 1163 1165 nand2_x0
xsubckt_763_nor2_x0 1 0 1127 1128 1129 nor2_x0
xsubckt_895_nand2_x0 1 0 1026 434 703 nand2_x0
xsubckt_1221_nand2_x0 1 0 1637 777 779 nand2_x0
xsubckt_1400_dff_x1 1 0 1818 676 356 dff_x1
xsubckt_537_nand2_x0 1 0 1797 1301 1303 nand2_x0
xsubckt_509_and2_x1 1 0 1322 589 703 and2_x1
xsubckt_421_and2_x1 1 0 1389 566 703 and2_x1
xsubckt_1406_dff_x1 1 0 1812 676 362 dff_x1
xsubckt_1405_dff_x1 1 0 1813 676 361 dff_x1
xsubckt_1404_dff_x1 1 0 1814 676 360 dff_x1
xsubckt_1403_dff_x1 1 0 1815 676 359 dff_x1
xsubckt_1402_dff_x1 1 0 1816 676 358 dff_x1
xsubckt_1401_dff_x1 1 0 1817 676 357 dff_x1
xsubckt_433_nand4_x0 1 0 1380 1585 353 702 675 nand4_x0
xsubckt_90_xor2_x0 1 0 353 221 220 xor2_x0
xsubckt_51_xor2_x0 1 0 314 135 134 xor2_x0
xsubckt_220_nand2_x0 1 0 1871 1544 1546 nand2_x0
xsubckt_700_nand2_x0 1 0 1759 1176 1178 nand2_x0
xsubckt_891_and2_x1 1 0 1029 433 703 and2_x1
xsubckt_908_and21nor_x0 1 0 1016 20 1583 1017 and21nor_x0
xsubckt_927_nand2_x0 1 0 1706 1002 1005 nand2_x0
xsubckt_1224_and21nor_x0 1 0 774 23 1583 775 and21nor_x0
xsubckt_1277_and3_x1 1 0 738 741 743 260 and3_x1
xsubckt_1409_dff_x1 1 0 1809 676 365 dff_x1
xsubckt_1408_dff_x1 1 0 1810 676 364 dff_x1
xsubckt_1407_dff_x1 1 0 1811 676 363 dff_x1
xsubckt_1363_dff_x1 1 0 1855 676 319 dff_x1
xsubckt_1362_dff_x1 1 0 1856 676 318 dff_x1
xsubckt_1361_dff_x1 1 0 1857 676 317 dff_x1
xsubckt_1360_dff_x1 1 0 1858 676 316 dff_x1
xsubckt_343_nand4_x0 1 0 1449 1585 332 702 675 nand4_x0
xsubckt_140_xor2_x0 1 0 403 77 76 xor2_x0
xsubckt_253_nand4_x0 1 0 1518 1585 311 702 675 nand4_x0
xsubckt_813_and2_x1 1 0 1089 667 703 and2_x1
xsubckt_837_nand2_x0 1 0 1071 1583 3 nand2_x0
xsubckt_852_and2_x1 1 0 1059 423 703 and2_x1
xsubckt_964_nand3_x0 1 0 1697 974 975 976 nand3_x0
xsubckt_1088_nand2_x0 1 0 1668 879 881 nand2_x0
xsubckt_1369_dff_x1 1 0 1849 676 325 dff_x1
xsubckt_1368_dff_x1 1 0 1850 676 324 dff_x1
xsubckt_1367_dff_x1 1 0 1851 676 323 dff_x1
xsubckt_1366_dff_x1 1 0 1852 676 322 dff_x1
xsubckt_1365_dff_x1 1 0 1853 676 321 dff_x1
xsubckt_1364_dff_x1 1 0 1854 676 320 dff_x1
xsubckt_364_and2_x1 1 0 1433 551 703 and2_x1
xsubckt_101_xor2_x0 1 0 364 246 245 xor2_x0
xsubckt_86_xor2_x0 1 0 349 213 212 xor2_x0
xsubckt_47_xor2_x0 1 0 310 126 125 xor2_x0
xsubckt_657_nand2_x0 1 0 1769 1209 1211 nand2_x0
xsubckt_747_nand2_x0 1 0 1748 1140 1143 nand2_x0
xsubckt_848_and2_x1 1 0 1062 422 703 and2_x1
xsubckt_887_and2_x1 1 0 1032 432 703 and2_x1
xsubckt_1172_and2_x1 1 0 814 561 703 and2_x1
xsubckt_1251_nand2_x0 1 0 1630 754 757 nand2_x0
xsubckt_575_nor2_x0 1 0 1271 1272 1273 nor2_x0
xsubckt_567_nand2_x0 1 0 1790 1278 1281 nand2_x0
xsubckt_136_xor2_x0 1 0 399 69 68 xor2_x0
xsubckt_809_and2_x1 1 0 1092 666 703 and2_x1
xsubckt_1071_and21nor_x0 1 0 891 62 1583 892 and21nor_x0
xsubckt_510_and21nor_x0 1 0 1321 172 1583 1322 and21nor_x0
xsubckt_730_nand2_x0 1 0 1752 1153 1155 nand2_x0
xsubckt_1106_nand4_x0 1 0 865 1585 33 702 675 nand4_x0
xsubckt_1320_nand3_x0 1 0 711 713 274 273 nand3_x0
xsubckt_640_nand2_x0 1 0 1222 1583 206 nand2_x0
xsubckt_306_and21nor_x0 1 0 1477 118 1583 1478 and21nor_x0
xsubckt_625_and2_x1 1 0 1233 619 703 and2_x1
xsubckt_610_and21nor_x0 1 0 1244 197 1583 1245 and21nor_x0
xsubckt_460_nand2_x0 1 0 1815 1360 1362 nand2_x0
xsubckt_664_and2_x1 1 0 1203 629 703 and2_x1
xsubckt_687_nand2_x0 1 0 1762 1186 1188 nand2_x0
xsubckt_699_and21nor_x0 1 0 1176 220 1583 1177 and21nor_x0
xsubckt_777_nand2_x0 1 0 1741 1117 1119 nand2_x0
xsubckt_840_nor2_x0 1 0 1068 1069 1070 nor2_x0
xsubckt_419_nand2_x0 1 0 1391 1583 149 nand2_x0
xsubckt_850_nand2_x0 1 0 1724 1061 1064 nand2_x0
xsubckt_940_nand2_x0 1 0 992 1583 29 nand2_x0
xsubckt_1191_nand2_x0 1 0 1644 800 803 nand2_x0
xsubckt_1328_and4_x1 1 0 707 710 271 270 269 and4_x1
xsubckt_239_nand2_x0 1 0 1529 1583 102 nand2_x0
xsubckt_280_nand2_x0 1 0 1857 1498 1500 nand2_x0
xsubckt_760_nand2_x0 1 0 1130 1583 237 nand2_x0
xsubckt_629_nand2_x0 1 0 1230 620 703 nand2_x0
xsubckt_580_nand2_x0 1 0 1787 1268 1270 nand2_x0
xsubckt_810_and21nor_x0 1 0 1091 249 1583 1092 and21nor_x0
xsubckt_1275_and4_x1 1 0 739 740 745 750 1583 and4_x1
xsubckt_1600_dff_x1 1 0 1619 676 260 dff_x1
xsubckt_402_nand2_x0 1 0 1829 1404 1406 nand2_x0
xsubckt_312_nand2_x0 1 0 1850 1473 1476 nand2_x0
xsubckt_925_and2_x1 1 0 1003 442 703 and2_x1
xsubckt_1170_nand3_x0 1 0 1649 816 817 818 nand3_x0
xsubckt_1262_and3_x1 1 0 747 750 1583 278 and3_x1
xsubckt_1605_dff_x1 1 0 1614 676 285 dff_x1
xsubckt_1604_dff_x1 1 0 1615 676 286 dff_x1
xsubckt_1603_dff_x1 1 0 1616 676 287 dff_x1
xsubckt_1602_dff_x1 1 0 1617 676 288 dff_x1
xsubckt_1601_dff_x1 1 0 1618 676 259 dff_x1
xsubckt_606_and21nor_x0 1 0 1247 196 1583 1248 and21nor_x0
xsubckt_71_xor2_x0 1 0 334 180 179 xor2_x0
xsubckt_652_nor2_x0 1 0 1212 1213 1214 nor2_x0
xsubckt_1210_and2_x1 1 0 785 661 703 and2_x1
xsubckt_1609_dff_x1 1 0 1610 676 281 dff_x1
xsubckt_1608_dff_x1 1 0 1611 676 282 dff_x1
xsubckt_1607_dff_x1 1 0 1612 676 283 dff_x1
xsubckt_1606_dff_x1 1 0 1613 676 284 dff_x1
xsubckt_1562_dff_x1 1 0 1656 676 49 dff_x1
xsubckt_1561_dff_x1 1 0 1657 676 47 dff_x1
xsubckt_1560_dff_x1 1 0 1658 676 44 dff_x1
xsubckt_353_and21nor_x0 1 0 1441 130 1583 1442 and21nor_x0
xsubckt_32_xor2_x0 1 0 295 93 92 xor2_x0
xsubckt_310_and2_x1 1 0 1474 536 703 and2_x1
xsubckt_754_and21nor_x0 1 0 1134 235 1583 1135 and21nor_x0
xsubckt_1206_and2_x1 1 0 788 650 703 and2_x1
xsubckt_1568_dff_x1 1 0 1650 676 62 dff_x1
xsubckt_1567_dff_x1 1 0 1651 676 60 dff_x1
xsubckt_1566_dff_x1 1 0 1652 676 58 dff_x1
xsubckt_1565_dff_x1 1 0 1653 676 55 dff_x1
xsubckt_1564_dff_x1 1 0 1654 676 53 dff_x1
xsubckt_1563_dff_x1 1 0 1655 676 51 dff_x1
xsubckt_432_nand2_x0 1 0 1822 1381 1384 nand2_x0
xsubckt_121_xor2_x0 1 0 384 36 35 xor2_x0
xsubckt_28_xor2_x0 1 0 291 84 83 xor2_x0
xsubckt_67_xor2_x0 1 0 330 171 170 xor2_x0
xsubckt_179_nand2_x0 1 0 1881 1575 1577 nand2_x0
xsubckt_645_nand4_x0 1 0 1218 1585 403 702 675 nand4_x0
xsubckt_735_nand4_x0 1 0 1149 1585 95 702 675 nand4_x0
xsubckt_749_nand2_x0 1 0 1138 651 703 nand2_x0
xsubckt_1052_and4_x1 1 0 906 1585 5 702 675 and4_x1
xsubckt_1569_dff_x1 1 0 1649 676 64 dff_x1
xsubckt_342_nand2_x0 1 0 1843 1450 1452 nand2_x0
xsubckt_117_xor2_x0 1 0 380 27 26 xor2_x0
xsubckt_199_nor2_x0 1 0 1559 1560 1561 nor2_x0
xsubckt_780_and2_x1 1 0 1114 658 703 and2_x1
xsubckt_465_nand4_x0 1 0 1356 1585 361 702 675 nand4_x0
xsubckt_405_and21nor_x0 1 0 1401 143 1583 1402 and21nor_x0
xsubckt_252_nand2_x0 1 0 1864 1519 1522 nand2_x0
xsubckt_292_and2_x1 1 0 1488 532 703 and2_x1
xsubckt_297_and21nor_x0 1 0 1484 116 1583 1485 and21nor_x0
xsubckt_806_and21nor_x0 1 0 1094 248 1583 1095 and21nor_x0
xsubckt_945_nand4_x0 1 0 988 1585 204 702 675 nand4_x0
xsubckt_389_nand2_x0 1 0 1832 1414 1417 nand2_x0
xsubckt_214_and2_x1 1 0 1548 512 703 and2_x1
xsubckt_299_nand2_x0 1 0 1483 1583 117 nand2_x0
xsubckt_798_and21nor_x0 1 0 1100 246 1583 1101 and21nor_x0
xsubckt_689_nand2_x0 1 0 1184 635 703 nand2_x0
xsubckt_1057_and2_x1 1 0 902 476 703 and2_x1
xsubckt_1105_nand2_x0 1 0 1664 866 869 nand2_x0
xsubckt_599_nand2_x0 1 0 1253 1583 195 nand2_x0
xsubckt_1015_nand2_x0 1 0 1685 935 937 nand2_x0
xsubckt_1018_and2_x1 1 0 932 466 703 and2_x1
xsubckt_1228_nand4_x0 1 0 771 1585 211 702 675 nand4_x0
xsubckt_592_and2_x1 1 0 1258 610 703 and2_x1
xsubckt_975_and4_x1 1 0 965 1585 219 702 675 and4_x1
xsubckt_514_and2_x1 1 0 1318 590 703 and2_x1
xsubckt_329_nor2_x0 1 0 1459 1460 1461 nor2_x0
xsubckt_998_and21nor_x0 1 0 947 43 1583 948 and21nor_x0
xsubckt_1225_nand2_x0 1 0 1636 774 776 nand2_x0
xsubckt_1318_and2_x1 1 0 712 713 274 and2_x1
xsubckt_597_and21nor_x0 1 0 1254 194 1583 1255 and21nor_x0
xsubckt_984_and2_x1 1 0 958 457 703 and2_x1
xsubckt_1413_dff_x1 1 0 1805 676 369 dff_x1
xsubckt_1412_dff_x1 1 0 1806 676 368 dff_x1
xsubckt_1411_dff_x1 1 0 1807 676 367 dff_x1
xsubckt_1410_dff_x1 1 0 1808 676 366 dff_x1
xsubckt_437_nand4_x0 1 0 1377 1585 354 702 675 nand4_x0
xsubckt_395_and4_x1 1 0 1409 1585 344 702 675 and4_x1
xsubckt_853_and21nor_x0 1 0 1058 6 1583 1059 and21nor_x0
xsubckt_1045_nor2_x0 1 0 911 912 913 nor2_x0
xsubckt_1419_dff_x1 1 0 1799 676 375 dff_x1
xsubckt_1418_dff_x1 1 0 1800 676 374 dff_x1
xsubckt_1417_dff_x1 1 0 1801 676 373 dff_x1
xsubckt_1416_dff_x1 1 0 1802 676 372 dff_x1
xsubckt_1415_dff_x1 1 0 1803 676 371 dff_x1
xsubckt_1414_dff_x1 1 0 1804 676 370 dff_x1
xsubckt_1370_dff_x1 1 0 1848 676 326 dff_x1
xsubckt_496_and2_x1 1 0 1332 586 703 and2_x1
xsubckt_91_xor2_x0 1 0 354 224 223 xor2_x0
xsubckt_52_xor2_x0 1 0 315 137 136 xor2_x0
xsubckt_257_nand4_x0 1 0 1515 1585 312 702 675 nand4_x0
xsubckt_792_nand2_x0 1 0 1105 1583 245 nand2_x0
xsubckt_1376_dff_x1 1 0 1842 676 332 dff_x1
xsubckt_1375_dff_x1 1 0 1843 676 331 dff_x1
xsubckt_1374_dff_x1 1 0 1844 676 330 dff_x1
xsubckt_1373_dff_x1 1 0 1845 676 329 dff_x1
xsubckt_1372_dff_x1 1 0 1846 676 328 dff_x1
xsubckt_1371_dff_x1 1 0 1847 676 327 dff_x1
xsubckt_141_xor2_x0 1 0 404 80 79 xor2_x0
xsubckt_102_xor2_x0 1 0 365 248 247 xor2_x0
xsubckt_87_xor2_x0 1 0 350 215 214 xor2_x0
xsubckt_48_xor2_x0 1 0 311 128 127 xor2_x0
xsubckt_167_nand4_x0 1 0 1584 1585 291 702 675 nand4_x0
xsubckt_1255_nand2_x0 1 0 1629 751 753 nand2_x0
xsubckt_1379_dff_x1 1 0 1839 676 335 dff_x1
xsubckt_1378_dff_x1 1 0 1840 676 334 dff_x1
xsubckt_1377_dff_x1 1 0 1841 676 333 dff_x1
xsubckt_552_and21nor_x0 1 0 1289 183 1583 1290 and21nor_x0
xsubckt_137_xor2_x0 1 0 400 71 70 xor2_x0
xsubckt_914_nand2_x0 1 0 1012 1583 22 nand2_x0
xsubckt_1134_and2_x1 1 0 843 496 703 and2_x1
xsubckt_1151_nand4_x0 1 0 830 1585 55 702 675 nand4_x0
xsubckt_1260_mux2_x1 1 0 289 749 1583 1626 mux2_x1
xsubckt_734_nand2_x0 1 0 1751 1150 1152 nand2_x0
xsubckt_1024_nand3_x0 1 0 1683 928 929 930 nand3_x0
xsubckt_630_nand4_x0 1 0 1229 1585 399 702 675 nand4_x0
xsubckt_644_nand2_x0 1 0 1772 1219 1222 nand2_x0
xsubckt_757_and2_x1 1 0 1132 653 703 and2_x1
xsubckt_1165_and21nor_x0 1 0 819 122 1583 820 and21nor_x0
xsubckt_1256_mux2_x1 1 0 674 257 675 1628 mux2_x1
xsubckt_564_and4_x1 1 0 1280 1585 384 702 675 and4_x1
xsubckt_554_nand2_x0 1 0 1288 1583 184 nand2_x0
xsubckt_464_nand2_x0 1 0 1814 1357 1359 nand2_x0
xsubckt_181_and2_x1 1 0 1573 503 703 and2_x1
xsubckt_767_nand4_x0 1 0 1124 1585 110 702 675 nand4_x0
xsubckt_968_nor2_x0 1 0 970 971 972 nor2_x0
xsubckt_1117_and21nor_x0 1 0 856 74 1583 857 and21nor_x0
xsubckt_409_nand4_x0 1 0 1398 1585 347 702 675 nand4_x0
xsubckt_944_nand2_x0 1 0 1702 989 992 nand2_x0
xsubckt_1195_nand2_x0 1 0 1643 797 799 nand2_x0
xsubckt_548_and21nor_x0 1 0 1292 182 1583 1293 and21nor_x0
xsubckt_177_and2_x1 1 0 1576 502 703 and2_x1
xsubckt_750_nand4_x0 1 0 1137 1585 102 702 675 nand4_x0
xsubckt_764_nand2_x0 1 0 1744 1127 1130 nand2_x0
xsubckt_854_nand2_x0 1 0 1723 1058 1060 nand2_x0
xsubckt_876_nor2_x0 1 0 1040 1041 1042 nor2_x0
xsubckt_1122_nor2_x0 1 0 852 853 854 nor2_x0
xsubckt_1303_nand4_x0 1 0 722 726 280 282 281 nand4_x0
xsubckt_623_nand3_x0 1 0 1777 1235 1236 1237 nand3_x0
xsubckt_451_and21nor_x0 1 0 1366 157 1583 1367 and21nor_x0
xsubckt_388_nor2_x0 1 0 1414 1415 1416 nor2_x0
xsubckt_160_nor4_x0 1 0 1591 285 286 284 283 nor4_x0
xsubckt_180_nand4_x0 1 0 1574 1585 294 702 675 nand4_x0
xsubckt_569_and2_x1 1 0 1276 604 703 and2_x1
xsubckt_494_nand2_x0 1 0 1334 1583 169 nand2_x0
xsubckt_429_and4_x1 1 0 1383 1585 352 702 675 and4_x1
xsubckt_406_nand2_x0 1 0 1828 1401 1403 nand2_x0
xsubckt_316_nand2_x0 1 0 1849 1470 1472 nand2_x0
xsubckt_1137_nand2_x0 1 0 841 1583 80 nand2_x0
xsubckt_1227_nand2_x0 1 0 772 451 703 nand2_x0
xsubckt_1612_dff_x1 1 0 1607 676 277 dff_x1
xsubckt_1611_dff_x1 1 0 1608 676 279 dff_x1
xsubckt_1610_dff_x1 1 0 1609 676 280 dff_x1
xsubckt_442_and2_x1 1 0 1373 571 703 and2_x1
xsubckt_390_nand4_x0 1 0 1413 1585 343 702 675 nand4_x0
xsubckt_156_nor4_x0 1 0 1595 273 272 271 270 nor4_x0
xsubckt_919_nand4_x0 1 0 1008 1585 191 702 675 nand4_x0
xsubckt_974_nand2_x0 1 0 966 1583 38 nand2_x0
xsubckt_1220_and21nor_x0 1 0 777 12 1583 778 and21nor_x0
xsubckt_1618_dff_x1 1 0 1601 676 271 dff_x1
xsubckt_1617_dff_x1 1 0 1602 676 272 dff_x1
xsubckt_1616_dff_x1 1 0 1603 676 273 dff_x1
xsubckt_1615_dff_x1 1 0 1604 676 274 dff_x1
xsubckt_1614_dff_x1 1 0 1605 676 275 dff_x1
xsubckt_1613_dff_x1 1 0 1606 676 276 dff_x1
xsubckt_1285_and2_x1 1 0 734 735 740 and2_x1
xsubckt_438_and2_x1 1 0 1376 570 703 and2_x1
xsubckt_349_nand4_x0 1 0 1444 1585 333 702 675 nand4_x0
xsubckt_33_xor2_x0 1 0 296 95 94 xor2_x0
xsubckt_72_xor2_x0 1 0 335 182 181 xor2_x0
xsubckt_1619_dff_x1 1 0 1600 676 270 dff_x1
xsubckt_1575_dff_x1 1 0 1643 676 77 dff_x1
xsubckt_1574_dff_x1 1 0 1644 676 75 dff_x1
xsubckt_1573_dff_x1 1 0 1645 676 73 dff_x1
xsubckt_1572_dff_x1 1 0 1646 676 71 dff_x1
xsubckt_1571_dff_x1 1 0 1647 676 69 dff_x1
xsubckt_1570_dff_x1 1 0 1648 676 66 dff_x1
xsubckt_122_xor2_x0 1 0 385 38 37 xor2_x0
xsubckt_68_xor2_x0 1 0 331 173 172 xor2_x0
xsubckt_690_nand4_x0 1 0 1183 1585 413 702 675 nand4_x0
xsubckt_739_nand4_x0 1 0 1146 1585 97 702 675 nand4_x0
xsubckt_834_and2_x1 1 0 1073 419 703 and2_x1
xsubckt_1579_dff_x1 1 0 1639 676 122 dff_x1
xsubckt_1578_dff_x1 1 0 1640 676 100 dff_x1
xsubckt_1577_dff_x1 1 0 1641 676 82 dff_x1
xsubckt_1576_dff_x1 1 0 1642 676 80 dff_x1
xsubckt_559_nand4_x0 1 0 1284 1585 383 702 675 nand4_x0
xsubckt_447_and21nor_x0 1 0 1369 155 1583 1370 and21nor_x0
xsubckt_436_nand2_x0 1 0 1821 1378 1380 nand2_x0
xsubckt_346_nand2_x0 1 0 1842 1447 1449 nand2_x0
xsubckt_29_xor2_x0 1 0 292 86 85 xor2_x0
xsubckt_641_and4_x1 1 0 1221 1585 402 702 675 and4_x1
xsubckt_1167_nand2_x0 1 0 818 1583 133 nand2_x0
xsubckt_1193_and2_x1 1 0 798 617 703 and2_x1
xsubckt_1243_nand4_x0 1 0 760 1585 45 702 675 nand4_x0
xsubckt_557_nor2_x0 1 0 1285 1286 1287 nor2_x0
xsubckt_118_xor2_x0 1 0 381 29 28 xor2_x0
xsubckt_256_nand2_x0 1 0 1863 1516 1518 nand2_x0
xsubckt_703_and2_x1 1 0 1173 638 703 and2_x1
xsubckt_812_nand4_x0 1 0 1090 1585 135 702 675 nand4_x0
xsubckt_949_nand4_x0 1 0 985 1585 206 702 675 nand4_x0
xsubckt_632_nand4_x0 1 0 1228 1585 400 702 675 nand4_x0
xsubckt_194_and21nor_x0 1 0 1563 90 1583 1564 and21nor_x0
xsubckt_254_and2_x1 1 0 1517 522 703 and2_x1
xsubckt_683_nand3_x0 1 0 1763 1189 1190 1191 nand3_x0
xsubckt_1062_and2_x1 1 0 898 477 703 and2_x1
xsubckt_1189_and2_x1 1 0 801 606 703 and2_x1
xsubckt_1331_nexor2_x0 1 0 707 700 1598 nexor2_x0
xsubckt_542_nand4_x0 1 0 1297 1585 379 702 675 nand4_x0
xsubckt_1060_nand2_x0 1 0 900 1583 60 nand2_x0
xsubckt_1109_nand2_x0 1 0 1663 863 865 nand2_x0
xsubckt_1150_nand2_x0 1 0 1654 831 834 nand2_x0
xsubckt_376_nand2_x0 1 0 1424 1583 137 nand2_x0
xsubckt_646_and2_x1 1 0 1217 624 703 and2_x1
xsubckt_647_and21nor_x0 1 0 1216 207 1583 1217 and21nor_x0
xsubckt_685_and2_x1 1 0 1187 634 703 and2_x1
xsubckt_932_nand4_x0 1 0 998 1585 197 702 675 nand4_x0
xsubckt_941_and4_x1 1 0 991 1585 202 702 675 and4_x1
xsubckt_951_and21nor_x0 1 0 983 31 1583 984 and21nor_x0
xsubckt_1183_nand4_x0 1 0 806 1585 73 702 675 nand4_x0
xsubckt_1304_nexor2_x0 1 0 723 689 1609 nexor2_x0
xsubckt_1301_and3_x1 1 0 723 726 282 281 and3_x1
xsubckt_499_nand4_x0 1 0 1330 1585 369 702 675 nand4_x0
xsubckt_158_and2_x1 1 0 1593 1594 1595 and2_x1
xsubckt_752_nand4_x0 1 0 1136 1585 104 702 675 nand4_x0
xsubckt_766_nand2_x0 1 0 1125 655 703 nand2_x0
xsubckt_842_nand4_x0 1 0 1067 1585 151 702 675 nand4_x0
xsubckt_979_nand4_x0 1 0 962 1585 221 702 675 nand4_x0
xsubckt_1093_nand4_x0 1 0 875 1585 27 702 675 nand4_x0
xsubckt_196_nand2_x0 1 0 1562 1583 91 nand2_x0
xsubckt_950_and2_x1 1 0 984 448 703 and2_x1
xsubckt_1325_nexor2_x0 1 0 710 697 1601 nexor2_x0
xsubckt_1296_and4_x1 1 0 726 727 733 285 286 and4_x1
xsubckt_408_nand2_x0 1 0 1399 563 703 nand2_x0
xsubckt_242_nor2_x0 1 0 1526 1527 1528 nor2_x0
xsubckt_911_and2_x1 1 0 1014 438 703 and2_x1
xsubckt_1420_dff_x1 1 0 1798 676 376 dff_x1
xsubckt_482_nand4_x0 1 0 1343 1585 365 702 675 nand4_x0
xsubckt_462_and2_x1 1 0 1358 577 703 and2_x1
xsubckt_304_nand4_x0 1 0 1479 1585 323 702 675 nand4_x0
xsubckt_907_and2_x1 1 0 1017 437 703 and2_x1
xsubckt_946_and2_x1 1 0 987 447 703 and2_x1
xsubckt_1231_and2_x1 1 0 769 462 703 and2_x1
xsubckt_1426_dff_x1 1 0 1792 676 382 dff_x1
xsubckt_1425_dff_x1 1 0 1793 676 381 dff_x1
xsubckt_1424_dff_x1 1 0 1794 676 380 dff_x1
xsubckt_1423_dff_x1 1 0 1795 676 379 dff_x1
xsubckt_1422_dff_x1 1 0 1796 676 378 dff_x1
xsubckt_1421_dff_x1 1 0 1797 676 377 dff_x1
xsubckt_604_nand4_x0 1 0 1249 1585 393 702 675 nand4_x0
xsubckt_458_and2_x1 1 0 1361 576 703 and2_x1
xsubckt_92_xor2_x0 1 0 355 226 225 xor2_x0
xsubckt_53_xor2_x0 1 0 316 139 138 xor2_x0
xsubckt_318_and4_x1 1 0 1468 1585 326 702 675 and4_x1
xsubckt_1212_nand2_x0 1 0 1639 784 786 nand2_x0
xsubckt_1429_dff_x1 1 0 1789 676 385 dff_x1
xsubckt_1428_dff_x1 1 0 1790 676 384 dff_x1
xsubckt_1427_dff_x1 1 0 1791 676 383 dff_x1
xsubckt_1383_dff_x1 1 0 1835 676 339 dff_x1
xsubckt_1382_dff_x1 1 0 1836 676 338 dff_x1
xsubckt_1381_dff_x1 1 0 1837 676 337 dff_x1
xsubckt_1380_dff_x1 1 0 1838 676 336 dff_x1
xsubckt_142_xor2_x0 1 0 405 82 81 xor2_x0
xsubckt_947_and21nor_x0 1 0 986 30 1583 987 and21nor_x0
xsubckt_1388_dff_x1 1 0 1830 676 344 dff_x1
xsubckt_1387_dff_x1 1 0 1831 676 343 dff_x1
xsubckt_1386_dff_x1 1 0 1832 676 342 dff_x1
xsubckt_1385_dff_x1 1 0 1833 676 341 dff_x1
xsubckt_1384_dff_x1 1 0 1834 676 340 dff_x1
xsubckt_424_nand4_x0 1 0 1387 1585 351 702 675 nand4_x0
xsubckt_348_nand2_x0 1 0 1445 546 703 nand2_x0
xsubckt_103_xor2_x0 1 0 366 250 249 xor2_x0
xsubckt_88_xor2_x0 1 0 351 217 216 xor2_x0
xsubckt_49_xor2_x0 1 0 312 130 129 xor2_x0
xsubckt_788_and4_x1 1 0 1108 1585 121 702 675 and4_x1
xsubckt_904_nand4_x0 1 0 1019 1585 182 702 675 nand4_x0
xsubckt_918_nand2_x0 1 0 1708 1009 1012 nand2_x0
xsubckt_1032_nand2_x0 1 0 1681 922 924 nand2_x0
xsubckt_1034_and4_x1 1 0 920 1585 250 702 675 and4_x1
xsubckt_1155_nand4_x0 1 0 827 1585 58 702 675 nand4_x0
xsubckt_1389_dff_x1 1 0 1829 676 345 dff_x1
xsubckt_1319_nexor2_x0 1 0 713 695 1604 nexor2_x0
xsubckt_1315_and21nor_x0 1 0 1606 693 716 714 and21nor_x0
xsubckt_401_and21nor_x0 1 0 1404 142 1583 1405 and21nor_x0
xsubckt_138_xor2_x0 1 0 401 73 72 xor2_x0
xsubckt_762_and2_x1 1 0 1128 654 703 and2_x1
xsubckt_802_and21nor_x0 1 0 1097 247 1583 1098 and21nor_x0
xsubckt_828_nand2_x0 1 0 1078 1583 254 nand2_x0
xsubckt_1270_nexor2_x0 1 0 744 679 1622 nexor2_x0
xsubckt_511_nand2_x0 1 0 1803 1321 1323 nand2_x0
xsubckt_274_and2_x1 1 0 1502 527 703 and2_x1
xsubckt_648_nand2_x0 1 0 1771 1216 1218 nand2_x0
xsubckt_738_nand2_x0 1 0 1750 1147 1149 nand2_x0
xsubckt_797_and2_x1 1 0 1101 663 703 and2_x1
xsubckt_1082_and2_x1 1 0 883 482 703 and2_x1
xsubckt_1242_nand2_x0 1 0 1632 761 764 nand2_x0
xsubckt_1291_nexor2_x0 1 0 732 685 1614 nexor2_x0
xsubckt_558_nand2_x0 1 0 1792 1285 1288 nand2_x0
xsubckt_501_and21nor_x0 1 0 1328 170 1583 1329 and21nor_x0
xsubckt_811_nand2_x0 1 0 1733 1091 1093 nand2_x0
xsubckt_901_nand2_x0 1 0 1712 1022 1024 nand2_x0
xsubckt_1282_nexor2_x0 1 0 737 288 1617 nexor2_x0
xsubckt_468_nand2_x0 1 0 1813 1354 1356 nand2_x0
xsubckt_345_and21nor_x0 1 0 1447 128 1583 1448 and21nor_x0
xsubckt_948_nand2_x0 1 0 1701 986 988 nand2_x0
xsubckt_1014_and21nor_x0 1 0 935 48 1583 936 and21nor_x0
xsubckt_1078_and2_x1 1 0 886 481 703 and2_x1
xsubckt_1311_nand3_x0 1 0 716 718 1583 277 nand3_x0
xsubckt_541_nand2_x0 1 0 1796 1298 1300 nand2_x0
xsubckt_500_and2_x1 1 0 1329 587 703 and2_x1
xsubckt_1281_and4_x1 1 0 736 739 259 260 288 and4_x1
xsubckt_574_and2_x1 1 0 1272 605 703 and2_x1
xsubckt_535_and2_x1 1 0 1302 596 703 and2_x1
xsubckt_184_nand4_x0 1 0 1571 1585 295 702 675 nand4_x0
xsubckt_161_nor4_x0 1 0 1590 280 279 282 281 nor4_x0
xsubckt_746_nor2_x0 1 0 1140 1141 1142 nor2_x0
xsubckt_841_nand2_x0 1 0 1726 1068 1071 nand2_x0
xsubckt_931_nand2_x0 1 0 1705 999 1001 nand2_x0
xsubckt_1041_nand3_x0 1 0 1679 915 916 917 nand3_x0
xsubckt_1092_nand2_x0 1 0 1667 876 878 nand2_x0
xsubckt_1182_nand2_x0 1 0 1646 807 809 nand2_x0
xsubckt_498_nand2_x0 1 0 1806 1331 1334 nand2_x0
xsubckt_157_nor4_x0 1 0 1594 269 268 266 265 nor4_x0
xsubckt_865_and4_x1 1 0 1049 1585 162 702 675 and4_x1
xsubckt_978_nand2_x0 1 0 1694 963 966 nand2_x0
xsubckt_1058_and21nor_x0 1 0 901 59 1583 902 and21nor_x0
xsubckt_1111_and4_x1 1 0 861 1585 36 702 675 and4_x1
xsubckt_1178_nand3_x0 1 0 1647 810 811 812 nand3_x0
xsubckt_1623_dff_x1 1 0 1596 676 265 dff_x1
xsubckt_1622_dff_x1 1 0 1597 676 266 dff_x1
xsubckt_1621_dff_x1 1 0 1598 676 268 dff_x1
xsubckt_1620_dff_x1 1 0 1599 676 269 dff_x1
xsubckt_571_nand2_x0 1 0 1789 1275 1277 nand2_x0
xsubckt_520_nand3_x0 1 0 1801 1314 1315 1316 nand3_x0
xsubckt_404_and2_x1 1 0 1402 560 703 and2_x1
xsubckt_377_and4_x1 1 0 1423 1585 340 702 675 and4_x1
xsubckt_73_xor2_x0 1 0 336 184 183 xor2_x0
xsubckt_1276_nexor2_x0 1 0 742 681 1620 nexor2_x0
xsubckt_1582_dff_x1 1 0 1636 676 189 dff_x1
xsubckt_1581_dff_x1 1 0 1637 676 167 dff_x1
xsubckt_1580_dff_x1 1 0 1638 676 144 dff_x1
xsubckt_481_nand2_x0 1 0 1810 1344 1346 nand2_x0
xsubckt_34_xor2_x0 1 0 297 97 96 xor2_x0
xsubckt_303_nand2_x0 1 0 1852 1480 1483 nand2_x0
xsubckt_961_nand2_x0 1 0 976 1583 35 nand2_x0
xsubckt_1588_dff_x1 1 0 1630 676 67 dff_x1
xsubckt_1587_dff_x1 1 0 1631 676 45 dff_x1
xsubckt_1586_dff_x1 1 0 1632 676 23 dff_x1
xsubckt_1585_dff_x1 1 0 1633 676 255 dff_x1
xsubckt_1584_dff_x1 1 0 1634 676 233 dff_x1
xsubckt_1583_dff_x1 1 0 1635 676 211 dff_x1
xsubckt_1297_nexor2_x0 1 0 729 688 1612 nexor2_x0
xsubckt_477_nand3_x0 1 0 1811 1347 1348 1349 nand3_x0
xsubckt_392_and21nor_x0 1 0 1411 140 1583 1412 and21nor_x0
xsubckt_123_xor2_x0 1 0 386 40 39 xor2_x0
xsubckt_69_xor2_x0 1 0 332 175 174 xor2_x0
xsubckt_906_nand4_x0 1 0 1018 1585 184 702 675 nand4_x0
xsubckt_1589_dff_x1 1 0 1629 676 145 dff_x1
xsubckt_1288_nexor2_x0 1 0 733 686 1615 nexor2_x0
xsubckt_603_nand2_x0 1 0 1782 1250 1253 nand2_x0
xsubckt_119_xor2_x0 1 0 382 31 30 xor2_x0
xsubckt_246_nand4_x0 1 0 1523 1585 309 702 675 nand4_x0
xsubckt_816_nand4_x0 1 0 1087 1585 137 702 675 nand4_x0
xsubckt_1067_nand4_x0 1 0 894 1585 11 702 675 nand4_x0
xsubckt_1116_and2_x1 1 0 857 491 703 and2_x1
xsubckt_636_nand4_x0 1 0 1225 1585 401 702 675 nand4_x0
xsubckt_492_and21nor_x0 1 0 1335 168 1583 1336 and21nor_x0
xsubckt_431_nor2_x0 1 0 1381 1382 1383 nor2_x0
xsubckt_423_nand2_x0 1 0 1824 1388 1391 nand2_x0
xsubckt_1161_and21nor_x0 1 0 822 111 1583 823 and21nor_x0
xsubckt_1230_nand4_x0 1 0 770 1585 233 702 675 nand4_x0
xsubckt_546_nand4_x0 1 0 1294 1585 380 702 675 nand4_x0
xsubckt_288_and21nor_x0 1 0 1491 114 1583 1492 and21nor_x0
xsubckt_651_and2_x1 1 0 1213 625 703 and2_x1
xsubckt_903_nand2_x0 1 0 1020 436 703 nand2_x0
xsubckt_991_nand2_x0 1 0 953 1583 42 nand2_x0
xsubckt_1154_nand2_x0 1 0 1653 828 830 nand2_x0
xsubckt_243_nand2_x0 1 0 1866 1526 1529 nand2_x0
xsubckt_936_nand4_x0 1 0 995 1585 199 702 675 nand4_x0
xsubckt_1064_nand2_x0 1 0 1674 897 900 nand2_x0
xsubckt_1098_and2_x1 1 0 871 487 703 and2_x1
xsubckt_544_and21nor_x0 1 0 1295 181 1583 1296 and21nor_x0
xsubckt_858_nor2_x0 1 0 1054 1055 1056 nor2_x0
xsubckt_897_nand3_x0 1 0 1713 1025 1026 1027 nand3_x0
xsubckt_1097_nand4_x0 1 0 872 1585 29 702 675 nand4_x0
xsubckt_198_and2_x1 1 0 1560 508 703 and2_x1
xsubckt_756_nand4_x0 1 0 1133 1585 106 702 675 nand4_x0
xsubckt_1104_nor2_x0 1 0 866 867 868 nor2_x0
xsubckt_1324_and2_x1 1 0 709 710 271 and2_x1
xsubckt_488_and21nor_x0 1 0 1338 166 1583 1339 and21nor_x0
xsubckt_1157_and21nor_x0 1 0 825 100 1583 826 and21nor_x0
xsubckt_486_nand4_x0 1 0 1340 1585 366 702 675 nand4_x0
xsubckt_183_nand2_x0 1 0 1880 1572 1574 nand2_x0
xsubckt_900_and21nor_x0 1 0 1022 18 1583 1023 and21nor_x0
xsubckt_989_and21nor_x0 1 0 954 41 1583 955 and21nor_x0
xsubckt_1433_dff_x1 1 0 1785 676 389 dff_x1
xsubckt_1432_dff_x1 1 0 1786 676 388 dff_x1
xsubckt_1431_dff_x1 1 0 1787 676 387 dff_x1
xsubckt_1430_dff_x1 1 0 1788 676 386 dff_x1
xsubckt_588_and21nor_x0 1 0 1261 192 1583 1262 and21nor_x0
xsubckt_892_and21nor_x0 1 0 1028 16 1583 1029 and21nor_x0
xsubckt_1271_and2_x1 1 0 742 743 262 and2_x1
xsubckt_1439_dff_x1 1 0 1779 676 395 dff_x1
xsubckt_1438_dff_x1 1 0 1780 676 394 dff_x1
xsubckt_1437_dff_x1 1 0 1781 676 393 dff_x1
xsubckt_1436_dff_x1 1 0 1782 676 392 dff_x1
xsubckt_1435_dff_x1 1 0 1783 676 391 dff_x1
xsubckt_1434_dff_x1 1 0 1784 676 390 dff_x1
xsubckt_1390_dff_x1 1 0 1828 676 346 dff_x1
xsubckt_608_nand4_x0 1 0 1246 1585 394 702 675 nand4_x0
xsubckt_93_xor2_x0 1 0 356 228 227 xor2_x0
xsubckt_54_xor2_x0 1 0 317 141 140 xor2_x0
xsubckt_231_and4_x1 1 0 1535 1585 306 702 675 and4_x1
xsubckt_844_and21nor_x0 1 0 1065 4 1583 1066 and21nor_x0
xsubckt_1395_dff_x1 1 0 1823 676 351 dff_x1
xsubckt_1394_dff_x1 1 0 1824 676 350 dff_x1
xsubckt_1393_dff_x1 1 0 1825 676 349 dff_x1
xsubckt_1392_dff_x1 1 0 1826 676 348 dff_x1
xsubckt_1391_dff_x1 1 0 1827 676 347 dff_x1
xsubckt_443_and21nor_x0 1 0 1372 154 1583 1373 and21nor_x0
xsubckt_393_nand2_x0 1 0 1831 1411 1413 nand2_x0
xsubckt_332_and2_x1 1 0 1457 542 703 and2_x1
xsubckt_143_xor2_x0 1 0 406 100 89 xor2_x0
xsubckt_104_xor2_x0 1 0 367 252 251 xor2_x0
xsubckt_89_xor2_x0 1 0 352 219 218 xor2_x0
xsubckt_873_nand2_x0 1 0 1043 1583 11 nand2_x0
xsubckt_1399_dff_x1 1 0 1819 676 355 dff_x1
xsubckt_1398_dff_x1 1 0 1820 676 354 dff_x1
xsubckt_1397_dff_x1 1 0 1821 676 353 dff_x1
xsubckt_1396_dff_x1 1 0 1822 676 352 dff_x1
xsubckt_328_and2_x1 1 0 1460 541 703 and2_x1
xsubckt_139_xor2_x0 1 0 402 75 74 xor2_x0
xsubckt_996_nand4_x0 1 0 949 1585 230 702 675 nand4_x0
xsubckt_1069_nand4_x0 1 0 893 1585 14 702 675 nand4_x0
xsubckt_1159_nand4_x0 1 0 824 1585 60 702 675 nand4_x0
xsubckt_411_nand4_x0 1 0 1397 1585 348 702 675 nand4_x0
xsubckt_190_and21nor_x0 1 0 1566 88 1583 1567 and21nor_x0
xsubckt_724_and2_x1 1 0 1157 644 703 and2_x1
xsubckt_1246_nand2_x0 1 0 1631 758 760 nand2_x0
xsubckt_236_and2_x1 1 0 1531 518 703 and2_x1
xsubckt_1005_and2_x1 1 0 942 463 703 and2_x1
xsubckt_1044_and2_x1 1 0 912 472 703 and2_x1
xsubckt_1142_nand4_x0 1 0 837 1585 51 702 675 nand4_x0
xsubckt_245_nand2_x0 1 0 1524 520 703 nand2_x0
xsubckt_815_nand2_x0 1 0 1732 1088 1090 nand2_x0
xsubckt_888_and21nor_x0 1 0 1031 15 1583 1032 and21nor_x0
xsubckt_1066_nand2_x0 1 0 895 478 703 nand2_x0
xsubckt_1216_nor2_x0 1 0 780 781 782 nor2_x0
xsubckt_1279_nand4_x0 1 0 737 741 743 259 260 nand4_x0
xsubckt_635_nand2_x0 1 0 1774 1226 1228 nand2_x0
xsubckt_439_and21nor_x0 1 0 1375 153 1583 1376 and21nor_x0
xsubckt_320_nor2_x0 1 0 1466 1467 1468 nor2_x0
xsubckt_1108_and21nor_x0 1 0 863 72 1583 864 and21nor_x0
xsubckt_545_nand2_x0 1 0 1795 1295 1297 nand2_x0
xsubckt_441_nand4_x0 1 0 1374 1585 355 702 675 nand4_x0
xsubckt_188_nand4_x0 1 0 1568 1585 296 702 675 nand4_x0
xsubckt_790_nor2_x0 1 0 1106 1107 1108 nor2_x0
xsubckt_351_nand4_x0 1 0 1443 1585 334 702 675 nand4_x0
xsubckt_162_nor4_x0 1 0 1589 277 276 275 274 nor4_x0
xsubckt_186_and21nor_x0 1 0 1569 87 1583 1570 and21nor_x0
xsubckt_845_nand2_x0 1 0 1725 1065 1067 nand2_x0
xsubckt_935_nand2_x0 1 0 1704 996 998 nand2_x0
xsubckt_971_and2_x1 1 0 968 454 703 and2_x1
xsubckt_1186_nand2_x0 1 0 1645 804 806 nand2_x0
xsubckt_483_and2_x1 1 0 1342 582 703 and2_x1
xsubckt_224_nor2_x0 1 0 1540 1541 1542 nor2_x0
xsubckt_261_nand4_x0 1 0 1512 1585 313 702 675 nand4_x0
xsubckt_755_nand2_x0 1 0 1746 1134 1136 nand2_x0
xsubckt_1096_nand2_x0 1 0 1666 873 875 nand2_x0
xsubckt_1239_and4_x1 1 0 763 1585 23 702 675 and4_x1
xsubckt_878_nand4_x0 1 0 1039 1585 169 702 675 nand4_x0
xsubckt_967_and2_x1 1 0 971 453 703 and2_x1
xsubckt_1287_and2_x1 1 0 732 733 286 and2_x1
xsubckt_485_nand2_x0 1 0 1809 1341 1343 nand2_x0
xsubckt_479_and2_x1 1 0 1345 581 703 and2_x1
xsubckt_391_and2_x1 1 0 1412 557 703 and2_x1
xsubckt_35_xor2_x0 1 0 298 99 98 xor2_x0
xsubckt_74_xor2_x0 1 0 337 186 185 xor2_x0
xsubckt_307_nand2_x0 1 0 1851 1477 1479 nand2_x0
xsubckt_801_and2_x1 1 0 1098 664 703 and2_x1
xsubckt_875_and2_x1 1 0 1041 428 703 and2_x1
xsubckt_1128_nand2_x0 1 0 848 1583 77 nand2_x0
xsubckt_1147_and4_x1 1 0 833 1585 53 702 675 and4_x1
xsubckt_1211_and21nor_x0 1 0 784 244 1583 785 and21nor_x0
xsubckt_1595_dff_x1 1 0 1624 676 267 dff_x1
xsubckt_1594_dff_x1 1 0 1625 676 278 dff_x1
xsubckt_1593_dff_x1 1 0 1626 676 289 dff_x1
xsubckt_1592_dff_x1 1 0 1627 676 290 dff_x1
xsubckt_1591_dff_x1 1 0 258 676 675 dff_x1
xsubckt_1590_dff_x1 1 0 1628 676 257 dff_x1
xsubckt_381_nand4_x0 1 0 1420 1585 341 702 675 nand4_x0
xsubckt_352_and2_x1 1 0 1442 547 703 and2_x1
xsubckt_124_xor2_x0 1 0 387 42 41 xor2_x0
xsubckt_203_nand4_x0 1 0 1556 1585 299 702 675 nand4_x0
xsubckt_965_nand2_x0 1 0 973 1583 36 nand2_x0
xsubckt_1038_nand2_x0 1 0 917 1583 54 nand2_x0
xsubckt_1121_and2_x1 1 0 853 492 703 and2_x1
xsubckt_1160_and2_x1 1 0 823 528 703 and2_x1
xsubckt_1599_dff_x1 1 0 1620 676 261 dff_x1
xsubckt_1598_dff_x1 1 0 1621 676 262 dff_x1
xsubckt_1597_dff_x1 1 0 1622 676 263 dff_x1
xsubckt_1596_dff_x1 1 0 1623 676 264 dff_x1
xsubckt_607_nand2_x0 1 0 1781 1247 1249 nand2_x0
xsubckt_524_nor2_x0 1 0 1310 1311 1312 nor2_x0
xsubckt_387_and2_x1 1 0 1415 556 703 and2_x1
xsubckt_1156_and2_x1 1 0 826 517 703 and2_x1
xsubckt_517_nand2_x0 1 0 1316 1583 174 nand2_x0
xsubckt_994_nor2_x0 1 0 950 951 952 nor2_x0
xsubckt_1021_nand2_x0 1 0 930 1583 50 nand2_x0
xsubckt_427_nand2_x0 1 0 1823 1385 1387 nand2_x0
xsubckt_200_nand2_x0 1 0 1876 1559 1562 nand2_x0
xsubckt_1158_nand2_x0 1 0 1652 825 827 nand2_x0
xsubckt_613_and2_x1 1 0 1242 615 703 and2_x1
xsubckt_341_and21nor_x0 1 0 1450 127 1583 1451 and21nor_x0
xsubckt_995_nand2_x0 1 0 1690 950 953 nand2_x0
xsubckt_1010_and21nor_x0 1 0 938 47 1583 939 and21nor_x0
xsubckt_1099_and21nor_x0 1 0 870 70 1583 871 and21nor_x0
xsubckt_1207_and21nor_x0 1 0 787 233 1583 788 and21nor_x0
xsubckt_1316_and4_x1 1 0 713 715 718 1583 275 and4_x1
xsubckt_609_and2_x1 1 0 1245 614 703 and2_x1
xsubckt_560_and2_x1 1 0 1283 602 703 and2_x1
xsubckt_420_and4_x1 1 0 1390 1585 350 702 675 and4_x1
xsubckt_686_and21nor_x0 1 0 1186 217 1583 1187 and21nor_x0
xsubckt_638_and21nor_x0 1 0 1223 205 1583 1224 and21nor_x0
xsubckt_1051_nand2_x0 1 0 907 1583 58 nand2_x0
xsubckt_1141_nand2_x0 1 0 1656 838 841 nand2_x0
xsubckt_1264_nand4_x0 1 0 746 750 1583 278 267 nand4_x0
xsubckt_556_and2_x1 1 0 1286 601 703 and2_x1
xsubckt_367_nand2_x0 1 0 1431 1583 135 nand2_x0
xsubckt_230_nand2_x0 1 0 1536 1583 99 nand2_x0
xsubckt_237_and21nor_x0 1 0 1530 101 1583 1531 and21nor_x0
xsubckt_620_nand2_x0 1 0 1237 1583 201 nand2_x0
xsubckt_833_nand4_x0 1 0 1074 1585 147 702 675 nand4_x0
xsubckt_1440_dff_x1 1 0 1778 676 396 dff_x1
xsubckt_440_nand2_x0 1 0 1820 1375 1377 nand2_x0
xsubckt_425_and2_x1 1 0 1386 567 703 and2_x1
xsubckt_337_and21nor_x0 1 0 1453 126 1583 1454 and21nor_x0
xsubckt_187_nand2_x0 1 0 1879 1569 1571 nand2_x0
xsubckt_667_nand2_x0 1 0 1201 1583 213 nand2_x0
xsubckt_847_and4_x1 1 0 1063 1585 153 702 675 and4_x1
xsubckt_1006_and21nor_x0 1 0 941 46 1583 942 and21nor_x0
xsubckt_1446_dff_x1 1 0 1772 676 402 dff_x1
xsubckt_1445_dff_x1 1 0 1773 676 401 dff_x1
xsubckt_1444_dff_x1 1 0 1774 676 400 dff_x1
xsubckt_1443_dff_x1 1 0 1775 676 399 dff_x1
xsubckt_1442_dff_x1 1 0 1776 676 398 dff_x1
xsubckt_1441_dff_x1 1 0 1777 676 397 dff_x1
xsubckt_1294_nand4_x0 1 0 728 731 733 284 283 nand4_x0
xsubckt_94_xor2_x0 1 0 357 230 229 xor2_x0
xsubckt_55_xor2_x0 1 0 318 143 142 xor2_x0
xsubckt_260_nand2_x0 1 0 1862 1513 1515 nand2_x0
xsubckt_821_and2_x1 1 0 1083 669 703 and2_x1
xsubckt_1449_dff_x1 1 0 1769 676 405 dff_x1
xsubckt_1448_dff_x1 1 0 1770 676 404 dff_x1
xsubckt_1447_dff_x1 1 0 1771 676 403 dff_x1
xsubckt_144_xor2_x0 1 0 407 122 111 xor2_x0
xsubckt_205_nand4_x0 1 0 1555 1585 300 702 675 nand4_x0
xsubckt_741_and21nor_x0 1 0 1144 231 1583 1145 and21nor_x0
xsubckt_817_and2_x1 1 0 1086 668 703 and2_x1
xsubckt_877_nand2_x0 1 0 1718 1040 1043 nand2_x0
xsubckt_1180_and2_x1 1 0 808 584 703 and2_x1
xsubckt_105_xor2_x0 1 0 368 254 253 xor2_x0
xsubckt_166_nand3_x0 1 0 1585 1586 1588 1593 nand3_x0
xsubckt_787_nand2_x0 1 0 1109 1583 243 nand2_x0
xsubckt_938_and21nor_x0 1 0 993 28 1583 994 and21nor_x0
xsubckt_1254_and21nor_x0 1 0 751 256 1583 752 and21nor_x0
xsubckt_241_and2_x1 1 0 1527 519 703 and2_x1
xsubckt_380_nand2_x0 1 0 1834 1421 1424 nand2_x0
xsubckt_202_nand2_x0 1 0 1557 509 703 nand2_x0
xsubckt_290_nand2_x0 1 0 1490 1583 115 nand2_x0
xsubckt_659_and4_x1 1 0 1207 1585 406 702 675 and4_x1
xsubckt_909_nand2_x0 1 0 1710 1016 1018 nand2_x0
xsubckt_1236_nand4_x0 1 0 765 1585 255 702 675 nand4_x0
xsubckt_633_and2_x1 1 0 1227 621 703 and2_x1
xsubckt_502_nand2_x0 1 0 1805 1328 1330 nand2_x0
xsubckt_235_nand4_x0 1 0 1532 1585 307 702 675 nand4_x0
xsubckt_680_nand2_x0 1 0 1191 1583 216 nand2_x0
xsubckt_785_and21nor_x0 1 0 1110 242 1583 1111 and21nor_x0
xsubckt_819_nand2_x0 1 0 1731 1085 1087 nand2_x0
xsubckt_983_nand4_x0 1 0 959 1585 224 702 675 nand4_x0
xsubckt_1056_nand4_x0 1 0 903 1585 7 702 675 nand4_x0
xsubckt_639_nand2_x0 1 0 1773 1223 1225 nand2_x0
xsubckt_590_nand2_x0 1 0 1260 1583 193 nand2_x0
xsubckt_540_and21nor_x0 1 0 1298 180 1583 1299 and21nor_x0
xsubckt_1233_nand2_x0 1 0 1634 768 770 nand2_x0
xsubckt_1310_and2_x1 1 0 717 718 1583 and2_x1
xsubckt_549_nand2_x0 1 0 1794 1292 1294 nand2_x0
xsubckt_737_and21nor_x0 1 0 1147 230 1583 1148 and21nor_x0
xsubckt_924_and4_x1 1 0 1004 1585 193 702 675 and4_x1
xsubckt_1229_nand3_x0 1 0 1635 771 772 773 nand3_x0
xsubckt_484_and21nor_x0 1 0 1341 165 1583 1342 and21nor_x0
xsubckt_445_nand4_x0 1 0 1371 1585 356 702 675 nand4_x0
xsubckt_939_nand2_x0 1 0 1703 993 995 nand2_x0
xsubckt_1153_and21nor_x0 1 0 828 89 1583 829 and21nor_x0
xsubckt_265_nand4_x0 1 0 1509 1585 314 702 675 nand4_x0
xsubckt_759_nand2_x0 1 0 1745 1131 1133 nand2_x0
xsubckt_933_and2_x1 1 0 997 444 703 and2_x1
xsubckt_985_and21nor_x0 1 0 957 40 1583 958 and21nor_x0
xsubckt_1199_nor2_x0 1 0 793 794 795 nor2_x0
xsubckt_159_nor4_x0 1 0 1592 259 260 288 287 nor4_x0
xsubckt_40_xor2_x0 1 0 303 110 109 xor2_x0
xsubckt_922_nand2_x0 1 0 1707 1006 1008 nand2_x0
xsubckt_929_and2_x1 1 0 1000 443 703 and2_x1
xsubckt_1253_and2_x1 1 0 752 673 703 and2_x1
xsubckt_1266_and3_x1 1 0 745 278 267 264 and3_x1
xsubckt_536_and21nor_x0 1 0 1301 179 1583 1302 and21nor_x0
xsubckt_489_nand2_x0 1 0 1808 1338 1340 nand2_x0
xsubckt_75_xor2_x0 1 0 338 188 187 xor2_x0
xsubckt_291_and4_x1 1 0 1489 1585 320 702 675 and4_x1
xsubckt_695_nor2_x0 1 0 1179 1180 1181 nor2_x0
xsubckt_832_nand2_x0 1 0 1728 1075 1078 nand2_x0
xsubckt_1049_and21nor_x0 1 0 908 57 1583 909 and21nor_x0
xsubckt_36_xor2_x0 1 0 299 102 101 xor2_x0
xsubckt_314_and2_x1 1 0 1471 537 703 and2_x1
xsubckt_742_nand2_x0 1 0 1749 1144 1146 nand2_x0
xsubckt_955_nand4_x0 1 0 980 1585 208 702 675 nand4_x0
xsubckt_969_nand2_x0 1 0 1696 970 973 nand2_x0
xsubckt_1249_and2_x1 1 0 755 562 703 and2_x1
xsubckt_1332_nand3_x0 1 0 705 707 268 266 nand3_x0
xsubckt_562_nand2_x0 1 0 1791 1282 1284 nand2_x0
xsubckt_125_xor2_x0 1 0 388 44 43 xor2_x0
xsubckt_295_nand4_x0 1 0 1486 1585 321 702 675 nand4_x0
xsubckt_383_and21nor_x0 1 0 1418 138 1583 1419 and21nor_x0
xsubckt_745_and2_x1 1 0 1141 649 703 and2_x1
xsubckt_784_and2_x1 1 0 1111 659 703 and2_x1
xsubckt_952_nand2_x0 1 0 1700 983 985 nand2_x0
xsubckt_1017_and4_x1 1 0 933 1585 241 702 675 and4_x1
xsubckt_595_nand4_x0 1 0 1256 1585 391 702 675 nand4_x0
xsubckt_591_and4_x1 1 0 1259 1585 390 702 675 and4_x1
xsubckt_472_nor2_x0 1 0 1350 1351 1352 nor2_x0
xsubckt_417_nand4_x0 1 0 1392 1585 349 702 675 nand4_x0
xsubckt_296_and2_x1 1 0 1485 533 703 and2_x1
xsubckt_917_nor2_x0 1 0 1009 1010 1011 nor2_x0
xsubckt_1030_and2_x1 1 0 923 469 703 and2_x1
xsubckt_1241_nor2_x0 1 0 761 762 763 nor2_x0
xsubckt_631_nand3_x0 1 0 1775 1229 1230 1231 nand3_x0
xsubckt_513_and4_x1 1 0 1319 1585 372 702 675 and4_x1
xsubckt_218_and2_x1 1 0 1545 513 703 and2_x1
xsubckt_884_and21nor_x0 1 0 1034 14 1583 1035 and21nor_x0
xsubckt_999_nand2_x0 1 0 1689 947 949 nand2_x0
xsubckt_1026_and2_x1 1 0 926 468 703 and2_x1
xsubckt_435_and21nor_x0 1 0 1378 152 1583 1379 and21nor_x0
xsubckt_414_nand2_x0 1 0 1826 1395 1397 nand2_x0
xsubckt_165_and2_x1 1 0 1586 1587 678 and2_x1
xsubckt_302_nor2_x0 1 0 1480 1481 1482 nor2_x0
xsubckt_768_nand3_x0 1 0 1743 1124 1125 1126 nand3_x0
xsubckt_1235_nand2_x0 1 0 766 473 703 nand2_x0
xsubckt_1330_and2_x1 1 0 706 707 268 and2_x1
xsubckt_279_and21nor_x0 1 0 1498 112 1583 1499 and21nor_x0
xsubckt_982_nand2_x0 1 0 1693 960 962 nand2_x0
xsubckt_1145_nand2_x0 1 0 1655 835 837 nand2_x0
xsubckt_596_and2_x1 1 0 1255 611 703 and2_x1
xsubckt_495_and4_x1 1 0 1333 1585 368 702 675 and4_x1
xsubckt_357_nand4_x0 1 0 1438 1585 335 702 675 nand4_x0
xsubckt_182_and21nor_x0 1 0 1572 86 1583 1573 and21nor_x0
xsubckt_234_nand2_x0 1 0 1868 1533 1536 nand2_x0
xsubckt_751_nand3_x0 1 0 1747 1137 1138 1139 nand3_x0
xsubckt_772_nor2_x0 1 0 1120 1121 1122 nor2_x0
xsubckt_1055_nand2_x0 1 0 1676 904 907 nand2_x0
xsubckt_1290_and3_x1 1 0 730 733 285 286 and3_x1
xsubckt_430_and2_x1 1 0 1382 568 703 and2_x1
xsubckt_284_nor2_x0 1 0 1494 1495 1496 nor2_x0
xsubckt_602_nor2_x0 1 0 1250 1251 1252 nor2_x0
xsubckt_444_nand2_x0 1 0 1819 1372 1374 nand2_x0
xsubckt_60_xor2_x0 1 0 323 155 154 xor2_x0
xsubckt_988_and2_x1 1 0 955 458 703 and2_x1
xsubckt_1453_dff_x1 1 0 1765 676 409 dff_x1
xsubckt_1452_dff_x1 1 0 1766 676 408 dff_x1
xsubckt_1451_dff_x1 1 0 1767 676 407 dff_x1
xsubckt_1450_dff_x1 1 0 1768 676 406 dff_x1
xsubckt_354_nand2_x0 1 0 1840 1441 1443 nand2_x0
xsubckt_820_nand4_x0 1 0 1084 1585 139 702 675 nand4_x0
xsubckt_861_and2_x1 1 0 1052 425 703 and2_x1
xsubckt_910_nand4_x0 1 0 1015 1585 186 702 675 nand4_x0
xsubckt_1175_nand2_x0 1 0 812 1583 156 nand2_x0
xsubckt_1273_and2_x1 1 0 741 262 261 and2_x1
xsubckt_1458_dff_x1 1 0 1760 676 414 dff_x1
xsubckt_1457_dff_x1 1 0 1761 676 413 dff_x1
xsubckt_1456_dff_x1 1 0 1762 676 412 dff_x1
xsubckt_1455_dff_x1 1 0 1763 676 411 dff_x1
xsubckt_1454_dff_x1 1 0 1764 676 410 dff_x1
xsubckt_579_and21nor_x0 1 0 1268 190 1583 1269 and21nor_x0
xsubckt_373_and2_x1 1 0 1426 553 703 and2_x1
xsubckt_110_xor2_x0 1 0 373 11 10 xor2_x0
xsubckt_95_xor2_x0 1 0 358 232 231 xor2_x0
xsubckt_56_xor2_x0 1 0 319 147 146 xor2_x0
xsubckt_209_nand4_x0 1 0 1552 1585 301 702 675 nand4_x0
xsubckt_264_nand2_x0 1 0 1861 1510 1512 nand2_x0
xsubckt_857_and2_x1 1 0 1055 424 703 and2_x1
xsubckt_957_nand4_x0 1 0 979 1585 210 702 675 nand4_x0
xsubckt_1129_and4_x1 1 0 847 1585 44 702 675 and4_x1
xsubckt_1459_dff_x1 1 0 1759 676 415 dff_x1
xsubckt_584_nor2_x0 1 0 1264 1265 1266 nor2_x0
xsubckt_550_nand4_x0 1 0 1291 1585 381 702 675 nand4_x0
xsubckt_145_xor2_x0 1 0 408 144 133 xor2_x0
xsubckt_106_xor2_x0 1 0 369 3 2 xor2_x0
xsubckt_178_and21nor_x0 1 0 1575 85 1583 1576 and21nor_x0
xsubckt_691_nand3_x0 1 0 1761 1183 1184 1185 nand3_x0
xsubckt_1103_and2_x1 1 0 867 488 703 and2_x1
xsubckt_506_nor2_x0 1 0 1324 1325 1326 nor2_x0
xsubckt_474_nand2_x0 1 0 1349 1583 163 nand2_x0
xsubckt_369_and2_x1 1 0 1429 552 703 and2_x1
xsubckt_835_and21nor_x0 1 0 1072 2 1583 1073 and21nor_x0
xsubckt_954_nand2_x0 1 0 981 449 703 nand2_x0
xsubckt_384_nand2_x0 1 0 1833 1418 1420 nand2_x0
xsubckt_864_nand2_x0 1 0 1050 1583 9 nand2_x0
xsubckt_294_nand2_x0 1 0 1854 1487 1490 nand2_x0
xsubckt_673_and2_x1 1 0 1196 631 703 and2_x1
xsubckt_987_nand4_x0 1 0 956 1585 226 702 675 nand4_x0
xsubckt_1095_and21nor_x0 1 0 873 69 1583 874 and21nor_x0
xsubckt_1203_and21nor_x0 1 0 790 222 1583 791 and21nor_x0
xsubckt_594_nand2_x0 1 0 1784 1257 1260 nand2_x0
xsubckt_416_nand2_x0 1 0 1393 565 703 nand2_x0
xsubckt_1100_nand2_x0 1 0 1665 870 872 nand2_x0
xsubckt_634_and21nor_x0 1 0 1226 204 1583 1227 and21nor_x0
xsubckt_490_nand4_x0 1 0 1337 1585 367 702 675 nand4_x0
xsubckt_326_nand2_x0 1 0 1462 1583 124 nand2_x0
xsubckt_185_and2_x1 1 0 1570 504 703 and2_x1
xsubckt_669_and2_x1 1 0 1199 630 703 and2_x1
xsubckt_970_nand4_x0 1 0 969 1585 217 702 675 nand4_x0
xsubckt_1133_nand4_x0 1 0 844 1585 47 702 675 nand4_x0
xsubckt_1284_and4_x1 1 0 735 259 260 288 287 and4_x1
xsubckt_449_nand4_x0 1 0 1368 1585 357 702 675 nand4_x0
xsubckt_359_nand4_x0 1 0 1437 1585 336 702 675 nand4_x0
xsubckt_894_nand2_x0 1 0 1027 1583 17 nand2_x0
xsubckt_612_nand4_x0 1 0 1243 1585 395 702 675 nand4_x0
xsubckt_450_and2_x1 1 0 1367 574 703 and2_x1
xsubckt_164_nor4_x0 1 0 1587 263 264 262 261 nor4_x0
xsubckt_269_nand4_x0 1 0 1506 1585 315 702 675 nand4_x0
xsubckt_333_and21nor_x0 1 0 1456 125 1583 1457 and21nor_x0
xsubckt_80_xor2_x0 1 0 343 199 198 xor2_x0
xsubckt_661_nor2_x0 1 0 1205 1206 1207 nor2_x0
xsubckt_1002_and21nor_x0 1 0 944 44 1583 945 and21nor_x0
xsubckt_1267_and3_x1 1 0 744 745 750 1583 and3_x1
xsubckt_1302_nexor2_x0 1 0 725 691 1610 nexor2_x0
xsubckt_446_and2_x1 1 0 1370 572 703 and2_x1
xsubckt_356_nand2_x0 1 0 1439 548 703 nand2_x0
xsubckt_41_xor2_x0 1 0 304 113 112 xor2_x0
xsubckt_702_and4_x1 1 0 1174 1585 416 702 675 and4_x1
xsubckt_829_and4_x1 1 0 1077 1585 143 702 675 and4_x1
xsubckt_836_nand2_x0 1 0 1727 1072 1074 nand2_x0
xsubckt_1163_nand4_x0 1 0 821 1585 62 702 675 nand4_x0
xsubckt_1215_and2_x1 1 0 781 672 703 and2_x1
xsubckt_1289_and2_x1 1 0 731 285 286 and2_x1
xsubckt_130_xor2_x0 1 0 393 55 54 xor2_x0
xsubckt_37_xor2_x0 1 0 300 104 103 xor2_x0
xsubckt_76_xor2_x0 1 0 339 191 190 xor2_x0
xsubckt_678_and21nor_x0 1 0 1192 215 1583 1193 and21nor_x0
xsubckt_1073_nand4_x0 1 0 890 1585 16 702 675 nand4_x0
xsubckt_1188_and4_x1 1 0 802 1585 75 702 675 and4_x1
xsubckt_126_xor2_x0 1 0 389 47 46 xor2_x0
xsubckt_711_and2_x1 1 0 1167 641 703 and2_x1
xsubckt_869_nand4_x0 1 0 1046 1585 164 702 675 nand4_x0
xsubckt_934_and21nor_x0 1 0 996 27 1583 997 and21nor_x0
xsubckt_1061_and4_x1 1 0 899 1585 9 702 675 and4_x1
xsubckt_1323_nexor2_x0 1 0 711 272 1602 nexor2_x0
xsubckt_249_and4_x1 1 0 1521 1585 310 702 675 and4_x1
xsubckt_905_nand3_x0 1 0 1711 1019 1020 1021 nand3_x0
xsubckt_1119_nand2_x0 1 0 855 1583 75 nand2_x0
xsubckt_1305_nexor2_x0 1 0 722 279 1608 nexor2_x0
xsubckt_372_nand4_x0 1 0 1427 1585 339 702 675 nand4_x0
xsubckt_208_nand2_x0 1 0 1874 1553 1555 nand2_x0
xsubckt_223_and2_x1 1 0 1541 514 703 and2_x1
xsubckt_262_and2_x1 1 0 1511 524 703 and2_x1
xsubckt_707_and2_x1 1 0 1170 640 703 and2_x1
xsubckt_1070_and2_x1 1 0 892 479 703 and2_x1
xsubckt_1194_and21nor_x0 1 0 797 200 1583 798 and21nor_x0
xsubckt_192_nand4_x0 1 0 1565 1585 297 702 675 nand4_x0
xsubckt_258_and2_x1 1 0 1514 523 703 and2_x1
xsubckt_1322_and4_x1 1 0 710 713 274 273 272 and4_x1
xsubckt_672_nand4_x0 1 0 1197 1585 409 702 675 nand4_x0
xsubckt_733_and21nor_x0 1 0 1150 229 1583 1151 and21nor_x0
xsubckt_986_nand2_x0 1 0 1692 957 959 nand2_x0
xsubckt_1317_nexor2_x0 1 0 714 694 1605 nexor2_x0
xsubckt_523_and2_x1 1 0 1311 592 703 and2_x1
xsubckt_480_and21nor_x0 1 0 1344 164 1583 1345 and21nor_x0
xsubckt_238_nand2_x0 1 0 1867 1530 1532 nand2_x0
xsubckt_718_nand2_x0 1 0 1162 1583 226 nand2_x0
xsubckt_882_nand4_x0 1 0 1036 1585 171 702 675 nand4_x0
xsubckt_1059_nand2_x0 1 0 1675 901 903 nand2_x0
xsubckt_628_nand2_x0 1 0 1231 1583 203 nand2_x0
xsubckt_981_and21nor_x0 1 0 960 39 1583 961 and21nor_x0
xsubckt_993_and2_x1 1 0 951 459 703 and2_x1
xsubckt_1503_dff_x1 1 0 1715 676 173 dff_x1
xsubckt_1502_dff_x1 1 0 1716 676 171 dff_x1
xsubckt_1501_dff_x1 1 0 1717 676 169 dff_x1
xsubckt_1500_dff_x1 1 0 1718 676 166 dff_x1
xsubckt_448_nand2_x0 1 0 1818 1369 1371 nand2_x0
xsubckt_221_nand2_x0 1 0 1543 1583 97 nand2_x0
xsubckt_1042_nand2_x0 1 0 914 1583 55 nand2_x0
xsubckt_1054_nor2_x0 1 0 904 905 906 nor2_x0
xsubckt_1132_nand2_x0 1 0 1658 845 848 nand2_x0
xsubckt_1509_dff_x1 1 0 1709 676 186 dff_x1
xsubckt_1508_dff_x1 1 0 1710 676 184 dff_x1
xsubckt_1507_dff_x1 1 0 1711 676 182 dff_x1
xsubckt_1506_dff_x1 1 0 1712 676 180 dff_x1
xsubckt_1505_dff_x1 1 0 1713 676 177 dff_x1
xsubckt_1504_dff_x1 1 0 1714 676 175 dff_x1
xsubckt_1460_dff_x1 1 0 1758 676 416 dff_x1
xsubckt_1329_nexor2_x0 1 0 708 699 1599 nexor2_x0
xsubckt_611_nand2_x0 1 0 1780 1244 1246 nand2_x0
xsubckt_532_and21nor_x0 1 0 1304 177 1583 1305 and21nor_x0
xsubckt_466_and2_x1 1 0 1355 578 703 and2_x1
xsubckt_61_xor2_x0 1 0 324 158 157 xor2_x0
xsubckt_228_and21nor_x0 1 0 1537 98 1583 1538 and21nor_x0
xsubckt_701_nand2_x0 1 0 1175 1583 221 nand2_x0
xsubckt_761_and4_x1 1 0 1129 1585 108 702 675 and4_x1
xsubckt_824_nand4_x0 1 0 1081 1585 141 702 675 nand4_x0
xsubckt_1280_nexor2_x0 1 0 738 682 1618 nexor2_x0
xsubckt_1465_dff_x1 1 0 1753 676 88 dff_x1
xsubckt_1464_dff_x1 1 0 1754 676 86 dff_x1
xsubckt_1463_dff_x1 1 0 1755 676 84 dff_x1
xsubckt_1462_dff_x1 1 0 1756 676 418 dff_x1
xsubckt_1461_dff_x1 1 0 1757 676 417 dff_x1
xsubckt_521_nand2_x0 1 0 1313 1583 175 nand2_x0
xsubckt_150_xor2_x0 1 0 413 255 244 xor2_x0
xsubckt_111_xor2_x0 1 0 374 14 13 xor2_x0
xsubckt_96_xor2_x0 1 0 359 235 234 xor2_x0
xsubckt_57_xor2_x0 1 0 320 149 148 xor2_x0
xsubckt_268_nand2_x0 1 0 1860 1507 1509 nand2_x0
xsubckt_729_and21nor_x0 1 0 1153 228 1583 1154 and21nor_x0
xsubckt_748_nand2_x0 1 0 1139 1583 234 nand2_x0
xsubckt_1469_dff_x1 1 0 1749 676 97 dff_x1
xsubckt_1468_dff_x1 1 0 1750 676 95 dff_x1
xsubckt_1467_dff_x1 1 0 1751 676 93 dff_x1
xsubckt_1466_dff_x1 1 0 1752 676 91 dff_x1
xsubckt_146_xor2_x0 1 0 409 167 156 xor2_x0
xsubckt_658_nand2_x0 1 0 1208 1583 210 nand2_x0
xsubckt_1143_and2_x1 1 0 836 498 703 and2_x1
xsubckt_1162_nand2_x0 1 0 1651 822 824 nand2_x0
xsubckt_107_xor2_x0 1 0 370 5 4 xor2_x0
xsubckt_1072_nand2_x0 1 0 1672 891 893 nand2_x0
xsubckt_1283_nexor2_x0 1 0 736 684 1616 nexor2_x0
xsubckt_247_nand3_x0 1 0 1865 1523 1524 1525 nand3_x0
xsubckt_868_nand2_x0 1 0 1720 1047 1050 nand2_x0
xsubckt_1068_nand3_x0 1 0 1673 894 895 896 nand3_x0
xsubckt_1090_and2_x1 1 0 877 485 703 and2_x1
xsubckt_1139_and2_x1 1 0 839 497 703 and2_x1
xsubckt_1245_and21nor_x0 1 0 758 78 1583 759 and21nor_x0
xsubckt_573_and4_x1 1 0 1273 1585 386 702 675 and4_x1
xsubckt_528_and21nor_x0 1 0 1307 176 1583 1308 and21nor_x0
xsubckt_278_and2_x1 1 0 1499 529 703 and2_x1
xsubckt_298_nand2_x0 1 0 1853 1484 1486 nand2_x0
xsubckt_778_nand2_x0 1 0 1116 1583 241 nand2_x0
xsubckt_880_and21nor_x0 1 0 1037 13 1583 1038 and21nor_x0
xsubckt_977_nor2_x0 1 0 963 964 965 nor2_x0
xsubckt_1086_and2_x1 1 0 880 483 703 and2_x1
xsubckt_1265_nexor2_x0 1 0 747 678 1624 nexor2_x0
xsubckt_410_nand3_x0 1 0 1827 1398 1399 1400 nand3_x0
xsubckt_688_nand2_x0 1 0 1185 1583 218 nand2_x0
xsubckt_1000_nand4_x0 1 0 946 1585 232 702 675 nand4_x0
xsubckt_598_nand2_x0 1 0 1783 1254 1256 nand2_x0
xsubckt_371_nand2_x0 1 0 1836 1428 1431 nand2_x0
xsubckt_275_and21nor_x0 1 0 1501 110 1583 1502 and21nor_x0
xsubckt_281_nand2_x0 1 0 1497 1583 113 nand2_x0
xsubckt_1131_nor2_x0 1 0 845 846 847 nor2_x0
xsubckt_543_and2_x1 1 0 1296 598 703 and2_x1
xsubckt_397_nor2_x0 1 0 1407 1408 1409 nor2_x0
xsubckt_191_nand2_x0 1 0 1878 1566 1568 nand2_x0
xsubckt_226_nand4_x0 1 0 1539 1585 305 702 675 nand4_x0
xsubckt_671_nand2_x0 1 0 1766 1198 1201 nand2_x0
xsubckt_706_nand4_x0 1 0 1171 1585 417 702 675 nand4_x0
xsubckt_776_and21nor_x0 1 0 1117 240 1583 1118 and21nor_x0
xsubckt_1047_nand4_x0 1 0 910 1585 3 702 675 nand4_x0
xsubckt_616_nand4_x0 1 0 1240 1585 396 702 675 nand4_x0
xsubckt_581_nand2_x0 1 0 1267 1583 191 nand2_x0
xsubckt_578_and2_x1 1 0 1269 607 703 and2_x1
xsubckt_539_and2_x1 1 0 1299 597 703 and2_x1
xsubckt_794_nand4_x0 1 0 1103 1585 124 702 675 nand4_x0
xsubckt_1268_nexor2_x0 1 0 746 264 1623 nexor2_x0
xsubckt_526_nand4_x0 1 0 1309 1585 375 702 675 nand4_x0
xsubckt_412_and2_x1 1 0 1396 564 703 and2_x1
xsubckt_350_nand3_x0 1 0 1841 1444 1445 1446 nand3_x0
xsubckt_1144_and21nor_x0 1 0 835 81 1583 836 and21nor_x0
xsubckt_81_xor2_x0 1 0 344 202 201 xor2_x0
xsubckt_42_xor2_x0 1 0 305 115 114 xor2_x0
xsubckt_881_nand2_x0 1 0 1717 1037 1039 nand2_x0
xsubckt_131_xor2_x0 1 0 394 58 57 xor2_x0
xsubckt_791_nand2_x0 1 0 1738 1106 1109 nand2_x0
xsubckt_843_and2_x1 1 0 1066 421 703 and2_x1
xsubckt_1077_nand4_x0 1 0 887 1585 18 702 675 nand4_x0
xsubckt_38_xor2_x0 1 0 301 106 105 xor2_x0
xsubckt_77_xor2_x0 1 0 340 193 192 xor2_x0
xsubckt_174_and21nor_x0 1 0 1578 84 1583 1579 and21nor_x0
xsubckt_650_and4_x1 1 0 1214 1585 404 702 675 and4_x1
xsubckt_839_and2_x1 1 0 1069 420 703 and2_x1
xsubckt_913_nand2_x0 1 0 1709 1013 1015 nand2_x0
xsubckt_566_nor2_x0 1 0 1278 1279 1280 nor2_x0
xsubckt_127_xor2_x0 1 0 390 49 48 xor2_x0
xsubckt_823_nand2_x0 1 0 1730 1082 1084 nand2_x0
xsubckt_1198_and2_x1 1 0 794 628 703 and2_x1
xsubckt_553_nand2_x0 1 0 1793 1289 1291 nand2_x0
xsubckt_197_and4_x1 1 0 1561 1585 298 702 675 and4_x1
xsubckt_286_nand4_x0 1 0 1493 1585 319 702 675 nand4_x0
xsubckt_1091_and21nor_x0 1 0 876 68 1583 877 and21nor_x0
xsubckt_374_and21nor_x0 1 0 1425 136 1583 1426 and21nor_x0
xsubckt_655_and2_x1 1 0 1210 626 703 and2_x1
xsubckt_676_nand4_x0 1 0 1194 1585 410 702 675 nand4_x0
xsubckt_694_and2_x1 1 0 1180 636 703 and2_x1
xsubckt_831_nor2_x0 1 0 1075 1076 1077 nor2_x0
xsubckt_586_nand4_x0 1 0 1263 1585 389 702 675 nand4_x0
xsubckt_1016_nand2_x0 1 0 934 1583 49 nand2_x0
xsubckt_1190_nor2_x0 1 0 800 801 802 nor2_x0
xsubckt_886_nand4_x0 1 0 1033 1585 173 702 675 nand4_x0
xsubckt_426_and21nor_x0 1 0 1385 150 1583 1386 and21nor_x0
xsubckt_251_nor2_x0 1 0 1519 1520 1521 nor2_x0
xsubckt_796_nand4_x0 1 0 1102 1585 126 702 675 nand4_x0
xsubckt_920_and2_x1 1 0 1007 441 703 and2_x1
xsubckt_1226_nand2_x0 1 0 773 1583 34 nand2_x0
xsubckt_1510_dff_x1 1 0 1708 676 188 dff_x1
xsubckt_1292_and3_x1 1 0 729 731 733 284 and3_x1
xsubckt_493_nand2_x0 1 0 1807 1335 1337 nand2_x0
xsubckt_471_and2_x1 1 0 1351 579 703 and2_x1
xsubckt_916_and2_x1 1 0 1010 439 703 and2_x1
xsubckt_973_nand2_x0 1 0 1695 967 969 nand2_x0
xsubckt_1046_nand2_x0 1 0 1678 911 914 nand2_x0
xsubckt_1087_and21nor_x0 1 0 879 66 1583 880 and21nor_x0
xsubckt_1136_nand2_x0 1 0 1657 842 844 nand2_x0
xsubckt_1240_and2_x1 1 0 762 484 703 and2_x1
xsubckt_1516_dff_x1 1 0 1702 676 202 dff_x1
xsubckt_1515_dff_x1 1 0 1703 676 199 dff_x1
xsubckt_1514_dff_x1 1 0 1704 676 197 dff_x1
xsubckt_1513_dff_x1 1 0 1705 676 195 dff_x1
xsubckt_1512_dff_x1 1 0 1706 676 193 dff_x1
xsubckt_1511_dff_x1 1 0 1707 676 191 dff_x1
xsubckt_327_and4_x1 1 0 1461 1585 328 702 675 and4_x1
xsubckt_62_xor2_x0 1 0 325 160 159 xor2_x0
xsubckt_225_nand2_x0 1 0 1870 1540 1543 nand2_x0
xsubckt_643_nor2_x0 1 0 1219 1220 1221 nor2_x0
xsubckt_705_nand2_x0 1 0 1758 1172 1175 nand2_x0
xsubckt_1169_nand4_x0 1 0 816 1585 64 702 675 nand4_x0
xsubckt_1519_dff_x1 1 0 1699 676 208 dff_x1
xsubckt_1518_dff_x1 1 0 1700 676 206 dff_x1
xsubckt_1517_dff_x1 1 0 1701 676 204 dff_x1
xsubckt_1472_dff_x1 1 0 1746 676 104 dff_x1
xsubckt_1471_dff_x1 1 0 1747 676 102 dff_x1
xsubckt_1470_dff_x1 1 0 1748 676 99 dff_x1
xsubckt_615_nand2_x0 1 0 1779 1241 1243 nand2_x0
xsubckt_525_nand2_x0 1 0 1800 1310 1313 nand2_x0
xsubckt_340_and2_x1 1 0 1451 544 703 and2_x1
xsubckt_151_xor2_x0 1 0 414 23 12 xor2_x0
xsubckt_301_and2_x1 1 0 1481 534 703 and2_x1
xsubckt_674_and21nor_x0 1 0 1195 214 1583 1196 and21nor_x0
xsubckt_793_nand2_x0 1 0 1104 662 703 nand2_x0
xsubckt_1478_dff_x1 1 0 1740 676 117 dff_x1
xsubckt_1477_dff_x1 1 0 1741 676 115 dff_x1
xsubckt_1476_dff_x1 1 0 1742 676 113 dff_x1
xsubckt_1475_dff_x1 1 0 1743 676 110 dff_x1
xsubckt_1474_dff_x1 1 0 1744 676 108 dff_x1
xsubckt_1473_dff_x1 1 0 1745 676 106 dff_x1
xsubckt_626_and21nor_x0 1 0 1232 202 1583 1233 and21nor_x0
xsubckt_112_xor2_x0 1 0 375 16 15 xor2_x0
xsubckt_97_xor2_x0 1 0 360 237 236 xor2_x0
xsubckt_58_xor2_x0 1 0 321 151 150 xor2_x0
xsubckt_719_and4_x1 1 0 1161 1585 86 702 675 and4_x1
xsubckt_930_and21nor_x0 1 0 999 26 1583 1000 and21nor_x0
xsubckt_1043_and4_x1 1 0 913 1585 254 702 675 and4_x1
xsubckt_1479_dff_x1 1 0 1739 676 119 dff_x1
xsubckt_336_and2_x1 1 0 1454 543 703 and2_x1
xsubckt_331_nand4_x0 1 0 1458 1585 329 702 675 nand4_x0
xsubckt_147_xor2_x0 1 0 410 189 178 xor2_x0
xsubckt_108_xor2_x0 1 0 371 7 6 xor2_x0
xsubckt_204_nand3_x0 1 0 1875 1556 1557 1558 nand3_x0
xsubckt_732_and2_x1 1 0 1151 646 703 and2_x1
xsubckt_771_and2_x1 1 0 1121 656 703 and2_x1
xsubckt_1076_nand2_x0 1 0 1671 888 890 nand2_x0
xsubckt_1166_nand2_x0 1 0 1650 819 821 nand2_x0
xsubckt_283_and2_x1 1 0 1495 530 703 and2_x1
xsubckt_943_nor2_x0 1 0 989 990 991 nor2_x0
xsubckt_601_and2_x1 1 0 1251 612 703 and2_x1
xsubckt_728_and2_x1 1 0 1154 645 703 and2_x1
xsubckt_826_and21nor_x0 1 0 1079 253 1583 1080 and21nor_x0
xsubckt_1013_and2_x1 1 0 936 465 703 and2_x1
xsubckt_1048_and2_x1 1 0 909 474 703 and2_x1
xsubckt_1298_nor2_x0 1 0 725 728 690 nor2_x0
xsubckt_375_nand2_x0 1 0 1835 1425 1427 nand2_x0
xsubckt_285_nand2_x0 1 0 1856 1494 1497 nand2_x0
xsubckt_855_nand2_x0 1 0 1057 1583 7 nand2_x0
xsubckt_1004_nand4_x0 1 0 943 1585 235 702 675 nand4_x0
xsubckt_1009_and2_x1 1 0 939 464 703 and2_x1
xsubckt_1196_nand2_x0 1 0 796 1583 211 nand2_x0
xsubckt_1326_and3_x1 1 0 708 710 271 270 and3_x1
xsubckt_583_and2_x1 1 0 1265 608 703 and2_x1
xsubckt_195_nand2_x0 1 0 1877 1563 1565 nand2_x0
xsubckt_765_nand2_x0 1 0 1126 1583 238 nand2_x0
xsubckt_966_and4_x1 1 0 972 1585 215 702 675 and4_x1
xsubckt_1313_and2_x1 1 0 715 277 276 and2_x1
xsubckt_1286_and4_x1 1 0 733 734 745 750 1583 and4_x1
xsubckt_585_nand2_x0 1 0 1786 1264 1267 nand2_x0
xsubckt_505_and2_x1 1 0 1325 588 703 and2_x1
xsubckt_407_nand2_x0 1 0 1400 1583 146 nand2_x0
xsubckt_675_nand2_x0 1 0 1765 1195 1197 nand2_x0
xsubckt_1309_and2_x1 1 0 718 719 734 and2_x1
xsubckt_491_and2_x1 1 0 1336 585 703 and2_x1
xsubckt_317_nand2_x0 1 0 1469 1583 121 nand2_x0
xsubckt_874_and4_x1 1 0 1042 1585 166 702 675 and4_x1
xsubckt_1120_and4_x1 1 0 854 1585 40 702 675 and4_x1
xsubckt_1124_nand4_x0 1 0 851 1585 42 702 675 nand4_x0
xsubckt_487_and2_x1 1 0 1339 583 703 and2_x1
xsubckt_386_and4_x1 1 0 1416 1585 342 702 675 and4_x1
xsubckt_82_xor2_x0 1 0 345 204 203 xor2_x0
xsubckt_213_nand4_x0 1 0 1549 1585 302 702 675 nand4_x0
xsubckt_885_nand2_x0 1 0 1716 1034 1036 nand2_x0
xsubckt_1036_nor2_x0 1 0 918 919 920 nor2_x0
xsubckt_1295_and2_x1 1 0 727 284 283 and2_x1
xsubckt_360_and2_x1 1 0 1436 549 703 and2_x1
xsubckt_324_and21nor_x0 1 0 1463 123 1583 1464 and21nor_x0
xsubckt_43_xor2_x0 1 0 306 117 116 xor2_x0
xsubckt_725_and21nor_x0 1 0 1156 227 1583 1157 and21nor_x0
xsubckt_883_and2_x1 1 0 1035 431 703 and2_x1
xcmpt_one_0 1 0 258 one_x1
xsubckt_132_xor2_x0 1 0 395 60 59 xor2_x0
xsubckt_39_xor2_x0 1 0 302 108 107 xor2_x0
xsubckt_78_xor2_x0 1 0 341 195 194 xor2_x0
xsubckt_168_and21nor_x0 1 0 1583 1585 702 703 and21nor_x0
xsubckt_805_and2_x1 1 0 1095 665 703 and2_x1
xsubckt_347_nand2_x0 1 0 1446 1583 129 nand2_x0
xsubckt_128_xor2_x0 1 0 391 51 50 xor2_x0
xsubckt_827_nand2_x0 1 0 1729 1079 1081 nand2_x0
xsubckt_879_and2_x1 1 0 1038 430 703 and2_x1
xsubckt_1125_and2_x1 1 0 850 493 703 and2_x1
xsubckt_1164_and2_x1 1 0 820 539 703 and2_x1
xsubckt_1168_nand2_x0 1 0 817 550 703 nand2_x0
xsubckt_163_and4_x1 1 0 1588 1589 1590 1591 1592 and4_x1
xsubckt_723_nand4_x0 1 0 1158 1585 88 702 675 nand4_x0
xsubckt_330_nand2_x0 1 0 1846 1459 1462 nand2_x0
xsubckt_660_and2_x1 1 0 1206 627 703 and2_x1
xsubckt_555_and4_x1 1 0 1287 1585 382 702 675 and4_x1
xsubckt_453_nand4_x0 1 0 1365 1585 358 702 675 nand4_x0
xsubckt_1185_and21nor_x0 1 0 804 178 1583 805 and21nor_x0
xsubckt_1237_nand3_x0 1 0 1633 765 766 767 nand3_x0
xsubckt_617_and2_x1 1 0 1239 616 703 and2_x1
xsubckt_363_nand4_x0 1 0 1434 1585 337 702 675 nand4_x0
xsubckt_271_and21nor_x0 1 0 1504 109 1583 1505 and21nor_x0
xsubckt_273_nand4_x0 1 0 1503 1585 316 702 675 nand4_x0
xsubckt_867_nor2_x0 1 0 1047 1048 1049 nor2_x0
xsubckt_1113_nor2_x0 1 0 859 860 861 nor2_x0
xsubckt_379_nor2_x0 1 0 1421 1422 1423 nor2_x0
xsubckt_663_nand4_x0 1 0 1204 1585 407 702 675 nand4_x0
xsubckt_1003_nand2_x0 1 0 1688 944 946 nand2_x0
xsubckt_963_nand4_x0 1 0 974 1585 213 702 675 nand4_x0
xsubckt_1523_dff_x1 1 0 1695 676 217 dff_x1
xsubckt_1522_dff_x1 1 0 1696 676 215 dff_x1
xsubckt_1521_dff_x1 1 0 1697 676 213 dff_x1
xsubckt_1520_dff_x1 1 0 1698 676 210 dff_x1
xsubckt_229_nand2_x0 1 0 1869 1537 1539 nand2_x0
xsubckt_709_nand2_x0 1 0 1757 1169 1171 nand2_x0
xsubckt_1202_and2_x1 1 0 791 639 703 and2_x1
xsubckt_1528_dff_x1 1 0 1690 676 228 dff_x1
xsubckt_1527_dff_x1 1 0 1691 676 226 dff_x1
xsubckt_1526_dff_x1 1 0 1692 676 224 dff_x1
xsubckt_1525_dff_x1 1 0 1693 676 221 dff_x1
xsubckt_1524_dff_x1 1 0 1694 676 219 dff_x1
xsubckt_619_nand2_x0 1 0 1778 1238 1240 nand2_x0
xsubckt_63_xor2_x0 1 0 326 162 161 xor2_x0
xsubckt_240_and4_x1 1 0 1528 1585 308 702 675 and4_x1
xsubckt_267_and21nor_x0 1 0 1507 108 1583 1508 and21nor_x0
xsubckt_783_nand4_x0 1 0 1112 1585 119 702 675 nand4_x0
xsubckt_972_and21nor_x0 1 0 967 37 1583 968 and21nor_x0
xsubckt_1123_nand2_x0 1 0 1660 852 855 nand2_x0
xsubckt_1213_nand2_x0 1 0 783 1583 255 nand2_x0
xsubckt_1529_dff_x1 1 0 1689 676 230 dff_x1
xsubckt_1485_dff_x1 1 0 1733 676 132 dff_x1
xsubckt_1484_dff_x1 1 0 1734 676 130 dff_x1
xsubckt_1483_dff_x1 1 0 1735 676 128 dff_x1
xsubckt_1482_dff_x1 1 0 1736 676 126 dff_x1
xsubckt_1481_dff_x1 1 0 1737 676 124 dff_x1
xsubckt_1480_dff_x1 1 0 1738 676 121 dff_x1
xsubckt_529_nand2_x0 1 0 1799 1307 1309 nand2_x0
xsubckt_152_xor2_x0 1 0 415 45 34 xor2_x0
xsubckt_113_xor2_x0 1 0 376 18 17 xor2_x0
xsubckt_98_xor2_x0 1 0 361 239 238 xor2_x0
xsubckt_59_xor2_x0 1 0 322 153 152 xor2_x0
xsubckt_170_and21nor_x0 1 0 1581 83 1583 1582 and21nor_x0
xsubckt_212_nand2_x0 1 0 1873 1550 1552 nand2_x0
xsubckt_219_and21nor_x0 1 0 1544 96 1583 1545 and21nor_x0
xsubckt_825_and2_x1 1 0 1080 670 703 and2_x1
xsubckt_960_nand2_x0 1 0 1698 977 979 nand2_x0
xsubckt_1033_nand2_x0 1 0 921 1583 53 nand2_x0
xsubckt_1489_dff_x1 1 0 1729 676 141 dff_x1
xsubckt_1488_dff_x1 1 0 1730 676 139 dff_x1
xsubckt_1487_dff_x1 1 0 1731 676 137 dff_x1
xsubckt_1486_dff_x1 1 0 1732 676 135 dff_x1
xsubckt_335_nand4_x0 1 0 1455 1585 330 702 675 nand4_x0
xsubckt_148_xor2_x0 1 0 411 211 200 xor2_x0
xsubckt_899_and2_x1 1 0 1023 435 703 and2_x1
xsubckt_956_nand3_x0 1 0 1699 980 981 982 nand3_x0
xsubckt_1184_and2_x1 1 0 805 595 703 and2_x1
xsubckt_512_nand2_x0 1 0 1320 1583 173 nand2_x0
xsubckt_109_xor2_x0 1 0 372 9 8 xor2_x0
xsubckt_210_and2_x1 1 0 1551 511 703 and2_x1
xsubckt_467_and21nor_x0 1 0 1354 161 1583 1355 and21nor_x0
xsubckt_206_and2_x1 1 0 1554 510 703 and2_x1
xsubckt_649_nand2_x0 1 0 1215 1583 208 nand2_x0
xsubckt_902_nand2_x0 1 0 1021 1583 19 nand2_x0
xsubckt_1053_and2_x1 1 0 905 475 703 and2_x1
xsubckt_469_nand2_x0 1 0 1353 1583 162 nand2_x0
xsubckt_418_nand3_x0 1 0 1825 1392 1393 1394 nand3_x0
xsubckt_990_nand2_x0 1 0 1691 954 956 nand2_x0
xsubckt_637_and2_x1 1 0 1224 622 703 and2_x1
xsubckt_722_nand2_x0 1 0 1754 1159 1162 nand2_x0
xsubckt_859_nand2_x0 1 0 1722 1054 1057 nand2_x0
xsubckt_871_and21nor_x0 1 0 1044 10 1583 1045 and21nor_x0
xsubckt_1008_nand4_x0 1 0 940 1585 237 702 675 nand4_x0
xsubckt_289_nand2_x0 1 0 1855 1491 1493 nand2_x0
xsubckt_769_nand2_x0 1 0 1123 1583 239 nand2_x0
xsubckt_589_nand2_x0 1 0 1785 1261 1263 nand2_x0
xsubckt_452_nand2_x0 1 0 1817 1366 1368 nand2_x0
xsubckt_362_nand2_x0 1 0 1838 1435 1437 nand2_x0
xsubckt_679_nand2_x0 1 0 1764 1192 1194 nand2_x0
xsubckt_721_nor2_x0 1 0 1159 1160 1161 nor2_x0
xsubckt_980_and2_x1 1 0 961 456 703 and2_x1
xsubckt_1218_nand4_x0 1 0 779 1585 167 702 675 nand4_x0
xsubckt_570_and21nor_x0 1 0 1275 187 1583 1276 and21nor_x0
xsubckt_233_nor2_x0 1 0 1533 1534 1535 nor2_x0
xsubckt_272_nand2_x0 1 0 1859 1504 1506 nand2_x0
xsubckt_1083_and21nor_x0 1 0 882 65 1583 883 and21nor_x0
xsubckt_1248_and4_x1 1 0 756 1585 67 702 675 and4_x1
xsubckt_1274_and3_x1 1 0 740 263 262 261 and3_x1
xsubckt_358_nand3_x0 1 0 1839 1438 1439 1440 nand3_x0
xsubckt_217_nand4_x0 1 0 1546 1585 303 702 675 nand4_x0
xsubckt_662_nand2_x0 1 0 1768 1205 1208 nand2_x0
xsubckt_889_nand2_x0 1 0 1715 1031 1033 nand2_x0
xsubckt_937_and2_x1 1 0 994 445 703 and2_x1
xsubckt_976_and2_x1 1 0 964 455 703 and2_x1
xsubckt_1261_and2_x1 1 0 748 750 1583 and2_x1
xsubckt_1336_dff_x1 1 0 1882 676 292 dff_x1
xsubckt_1335_dff_x1 1 0 1883 676 291 dff_x1
xsubckt_572_nand2_x0 1 0 1274 1583 188 nand2_x0
xsubckt_83_xor2_x0 1 0 346 206 205 xor2_x0
xsubckt_44_xor2_x0 1 0 307 119 118 xor2_x0
xsubckt_309_and4_x1 1 0 1475 1585 324 702 675 and4_x1
xsubckt_799_nand2_x0 1 0 1736 1100 1102 nand2_x0
xsubckt_1201_nand4_x0 1 0 792 1585 82 702 675 nand4_x0
.ends expmob2
