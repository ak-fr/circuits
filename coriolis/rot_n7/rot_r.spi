* Coriolis Structural SPICE Driver
* Generated on Apr 13, 2025, 17:33
* Cell/Subckt "rot_r".
*
* INTERF vss
* INTERF vdd
* INTERF rotated_bits[99]
* INTERF rotated_bits[98]
* INTERF rotated_bits[97]
* INTERF rotated_bits[96]
* INTERF rotated_bits[95]
* INTERF rotated_bits[94]
* INTERF rotated_bits[93]
* INTERF rotated_bits[92]
* INTERF rotated_bits[91]
* INTERF rotated_bits[90]
* INTERF rotated_bits[9]
* INTERF rotated_bits[89]
* INTERF rotated_bits[88]
* INTERF rotated_bits[87]
* INTERF rotated_bits[86]
* INTERF rotated_bits[85]
* INTERF rotated_bits[84]
* INTERF rotated_bits[83]
* INTERF rotated_bits[82]
* INTERF rotated_bits[81]
* INTERF rotated_bits[80]
* INTERF rotated_bits[8]
* INTERF rotated_bits[79]
* INTERF rotated_bits[78]
* INTERF rotated_bits[77]
* INTERF rotated_bits[76]
* INTERF rotated_bits[75]
* INTERF rotated_bits[74]
* INTERF rotated_bits[73]
* INTERF rotated_bits[72]
* INTERF rotated_bits[71]
* INTERF rotated_bits[70]
* INTERF rotated_bits[7]
* INTERF rotated_bits[69]
* INTERF rotated_bits[68]
* INTERF rotated_bits[67]
* INTERF rotated_bits[66]
* INTERF rotated_bits[65]
* INTERF rotated_bits[64]
* INTERF rotated_bits[63]
* INTERF rotated_bits[62]
* INTERF rotated_bits[61]
* INTERF rotated_bits[60]
* INTERF rotated_bits[6]
* INTERF rotated_bits[59]
* INTERF rotated_bits[58]
* INTERF rotated_bits[57]
* INTERF rotated_bits[56]
* INTERF rotated_bits[55]
* INTERF rotated_bits[54]
* INTERF rotated_bits[53]
* INTERF rotated_bits[52]
* INTERF rotated_bits[51]
* INTERF rotated_bits[50]
* INTERF rotated_bits[5]
* INTERF rotated_bits[49]
* INTERF rotated_bits[48]
* INTERF rotated_bits[47]
* INTERF rotated_bits[46]
* INTERF rotated_bits[45]
* INTERF rotated_bits[44]
* INTERF rotated_bits[43]
* INTERF rotated_bits[42]
* INTERF rotated_bits[41]
* INTERF rotated_bits[40]
* INTERF rotated_bits[4]
* INTERF rotated_bits[39]
* INTERF rotated_bits[38]
* INTERF rotated_bits[37]
* INTERF rotated_bits[36]
* INTERF rotated_bits[35]
* INTERF rotated_bits[34]
* INTERF rotated_bits[33]
* INTERF rotated_bits[32]
* INTERF rotated_bits[31]
* INTERF rotated_bits[30]
* INTERF rotated_bits[3]
* INTERF rotated_bits[29]
* INTERF rotated_bits[28]
* INTERF rotated_bits[27]
* INTERF rotated_bits[26]
* INTERF rotated_bits[25]
* INTERF rotated_bits[24]
* INTERF rotated_bits[23]
* INTERF rotated_bits[22]
* INTERF rotated_bits[21]
* INTERF rotated_bits[20]
* INTERF rotated_bits[2]
* INTERF rotated_bits[19]
* INTERF rotated_bits[18]
* INTERF rotated_bits[17]
* INTERF rotated_bits[16]
* INTERF rotated_bits[15]
* INTERF rotated_bits[14]
* INTERF rotated_bits[13]
* INTERF rotated_bits[127]
* INTERF rotated_bits[126]
* INTERF rotated_bits[125]
* INTERF rotated_bits[124]
* INTERF rotated_bits[123]
* INTERF rotated_bits[122]
* INTERF rotated_bits[121]
* INTERF rotated_bits[120]
* INTERF rotated_bits[12]
* INTERF rotated_bits[119]
* INTERF rotated_bits[118]
* INTERF rotated_bits[117]
* INTERF rotated_bits[116]
* INTERF rotated_bits[115]
* INTERF rotated_bits[114]
* INTERF rotated_bits[113]
* INTERF rotated_bits[112]
* INTERF rotated_bits[111]
* INTERF rotated_bits[110]
* INTERF rotated_bits[11]
* INTERF rotated_bits[109]
* INTERF rotated_bits[108]
* INTERF rotated_bits[107]
* INTERF rotated_bits[106]
* INTERF rotated_bits[105]
* INTERF rotated_bits[104]
* INTERF rotated_bits[103]
* INTERF rotated_bits[102]
* INTERF rotated_bits[101]
* INTERF rotated_bits[100]
* INTERF rotated_bits[10]
* INTERF rotated_bits[1]
* INTERF rotated_bits[0]
* INTERF k[6]
* INTERF k[5]
* INTERF k[4]
* INTERF k[3]
* INTERF k[2]
* INTERF k[1]
* INTERF k[0]
* INTERF bits[99]
* INTERF bits[98]
* INTERF bits[97]
* INTERF bits[96]
* INTERF bits[95]
* INTERF bits[94]
* INTERF bits[93]
* INTERF bits[92]
* INTERF bits[91]
* INTERF bits[90]
* INTERF bits[9]
* INTERF bits[89]
* INTERF bits[88]
* INTERF bits[87]
* INTERF bits[86]
* INTERF bits[85]
* INTERF bits[84]
* INTERF bits[83]
* INTERF bits[82]
* INTERF bits[81]
* INTERF bits[80]
* INTERF bits[8]
* INTERF bits[79]
* INTERF bits[78]
* INTERF bits[77]
* INTERF bits[76]
* INTERF bits[75]
* INTERF bits[74]
* INTERF bits[73]
* INTERF bits[72]
* INTERF bits[71]
* INTERF bits[70]
* INTERF bits[7]
* INTERF bits[69]
* INTERF bits[68]
* INTERF bits[67]
* INTERF bits[66]
* INTERF bits[65]
* INTERF bits[64]
* INTERF bits[63]
* INTERF bits[62]
* INTERF bits[61]
* INTERF bits[60]
* INTERF bits[6]
* INTERF bits[59]
* INTERF bits[58]
* INTERF bits[57]
* INTERF bits[56]
* INTERF bits[55]
* INTERF bits[54]
* INTERF bits[53]
* INTERF bits[52]
* INTERF bits[51]
* INTERF bits[50]
* INTERF bits[5]
* INTERF bits[49]
* INTERF bits[48]
* INTERF bits[47]
* INTERF bits[46]
* INTERF bits[45]
* INTERF bits[44]
* INTERF bits[43]
* INTERF bits[42]
* INTERF bits[41]
* INTERF bits[40]
* INTERF bits[4]
* INTERF bits[39]
* INTERF bits[38]
* INTERF bits[37]
* INTERF bits[36]
* INTERF bits[35]
* INTERF bits[34]
* INTERF bits[33]
* INTERF bits[32]
* INTERF bits[31]
* INTERF bits[30]
* INTERF bits[3]
* INTERF bits[29]
* INTERF bits[28]
* INTERF bits[27]
* INTERF bits[26]
* INTERF bits[25]
* INTERF bits[24]
* INTERF bits[23]
* INTERF bits[22]
* INTERF bits[21]
* INTERF bits[20]
* INTERF bits[2]
* INTERF bits[19]
* INTERF bits[18]
* INTERF bits[17]
* INTERF bits[16]
* INTERF bits[15]
* INTERF bits[14]
* INTERF bits[13]
* INTERF bits[127]
* INTERF bits[126]
* INTERF bits[125]
* INTERF bits[124]
* INTERF bits[123]
* INTERF bits[122]
* INTERF bits[121]
* INTERF bits[120]
* INTERF bits[12]
* INTERF bits[119]
* INTERF bits[118]
* INTERF bits[117]
* INTERF bits[116]
* INTERF bits[115]
* INTERF bits[114]
* INTERF bits[113]
* INTERF bits[112]
* INTERF bits[111]
* INTERF bits[110]
* INTERF bits[11]
* INTERF bits[109]
* INTERF bits[108]
* INTERF bits[107]
* INTERF bits[106]
* INTERF bits[105]
* INTERF bits[104]
* INTERF bits[103]
* INTERF bits[102]
* INTERF bits[101]
* INTERF bits[100]
* INTERF bits[10]
* INTERF bits[1]
* INTERF bits[0]

* Terminal models (aka standard cells) used througout all the hierarchy.
.include mux2_x1.spi
.include inv_x0.spi
.include diode_w1.spi
.include decap_w0.spi
.include tie.spi

* Non-terminal models (part of the user's design hierarchy).

.subckt rot_r 0 1 2 3 4 5 6 7 8 9 10 11 12 13 14 15 16 17 18 19 20 21 22 23 24 25 26 27 28 29 30 31 32 33 34 35 36 37 38 39 40 41 42 43 44 45 46 47 48 49 50 51 52 53 54 55 56 57 58 59 60 61 62 63 64 65 66 67 68 69 70 71 72 73 74 75 76 77 78 79 80 81 82 83 84 85 86 87 88 89 90 91 92 93 94 95 96 97 98 99 100 101 102 103 104 105 106 107 108 109 110 111 112 113 114 115 116 117 118 119 120 121 122 123 124 125 126 127 128 129 130 131 132 133 134 135 136 138 139 140 141 142 143 144 145 146 147 148 149 150 151 152 153 154 155 156 157 158 159 160 161 162 163 164 165 166 167 168 169 170 171 172 173 174 175 176 177 178 179 180 181 182 183 184 185 186 187 188 189 190 191 192 193 194 195 196 197 198 199 200 201 202 203 204 205 206 207 208 209 210 211 212 213 214 215 216 217 218 219 220 221 222 223 224 225 226 227 228 229 230 231 232 233 234 235 236 237 238 239 240 241 242 243 244 245 246 247 248 249 250 251 252 253 254 255 256 257 258 259 260 261 262 263 264 265
* NET     0 = vss
* NET     1 = vdd
* NET     2 = rotated_bits[99]
* NET     3 = rotated_bits[98]
* NET     4 = rotated_bits[97]
* NET     5 = rotated_bits[96]
* NET     6 = rotated_bits[95]
* NET     7 = rotated_bits[94]
* NET     8 = rotated_bits[93]
* NET     9 = rotated_bits[92]
* NET    10 = rotated_bits[91]
* NET    11 = rotated_bits[90]
* NET    12 = rotated_bits[9]
* NET    13 = rotated_bits[89]
* NET    14 = rotated_bits[88]
* NET    15 = rotated_bits[87]
* NET    16 = rotated_bits[86]
* NET    17 = rotated_bits[85]
* NET    18 = rotated_bits[84]
* NET    19 = rotated_bits[83]
* NET    20 = rotated_bits[82]
* NET    21 = rotated_bits[81]
* NET    22 = rotated_bits[80]
* NET    23 = rotated_bits[8]
* NET    24 = rotated_bits[79]
* NET    25 = rotated_bits[78]
* NET    26 = rotated_bits[77]
* NET    27 = rotated_bits[76]
* NET    28 = rotated_bits[75]
* NET    29 = rotated_bits[74]
* NET    30 = rotated_bits[73]
* NET    31 = rotated_bits[72]
* NET    32 = rotated_bits[71]
* NET    33 = rotated_bits[70]
* NET    34 = rotated_bits[7]
* NET    35 = rotated_bits[69]
* NET    36 = rotated_bits[68]
* NET    37 = rotated_bits[67]
* NET    38 = rotated_bits[66]
* NET    39 = rotated_bits[65]
* NET    40 = rotated_bits[64]
* NET    41 = rotated_bits[63]
* NET    42 = rotated_bits[62]
* NET    43 = rotated_bits[61]
* NET    44 = rotated_bits[60]
* NET    45 = rotated_bits[6]
* NET    46 = rotated_bits[59]
* NET    47 = rotated_bits[58]
* NET    48 = rotated_bits[57]
* NET    49 = rotated_bits[56]
* NET    50 = rotated_bits[55]
* NET    51 = rotated_bits[54]
* NET    52 = rotated_bits[53]
* NET    53 = rotated_bits[52]
* NET    54 = rotated_bits[51]
* NET    55 = rotated_bits[50]
* NET    56 = rotated_bits[5]
* NET    57 = rotated_bits[49]
* NET    58 = rotated_bits[48]
* NET    59 = rotated_bits[47]
* NET    60 = rotated_bits[46]
* NET    61 = rotated_bits[45]
* NET    62 = rotated_bits[44]
* NET    63 = rotated_bits[43]
* NET    64 = rotated_bits[42]
* NET    65 = rotated_bits[41]
* NET    66 = rotated_bits[40]
* NET    67 = rotated_bits[4]
* NET    68 = rotated_bits[39]
* NET    69 = rotated_bits[38]
* NET    70 = rotated_bits[37]
* NET    71 = rotated_bits[36]
* NET    72 = rotated_bits[35]
* NET    73 = rotated_bits[34]
* NET    74 = rotated_bits[33]
* NET    75 = rotated_bits[32]
* NET    76 = rotated_bits[31]
* NET    77 = rotated_bits[30]
* NET    78 = rotated_bits[3]
* NET    79 = rotated_bits[29]
* NET    80 = rotated_bits[28]
* NET    81 = rotated_bits[27]
* NET    82 = rotated_bits[26]
* NET    83 = rotated_bits[25]
* NET    84 = rotated_bits[24]
* NET    85 = rotated_bits[23]
* NET    86 = rotated_bits[22]
* NET    87 = rotated_bits[21]
* NET    88 = rotated_bits[20]
* NET    89 = rotated_bits[2]
* NET    90 = rotated_bits[19]
* NET    91 = rotated_bits[18]
* NET    92 = rotated_bits[17]
* NET    93 = rotated_bits[16]
* NET    94 = rotated_bits[15]
* NET    95 = rotated_bits[14]
* NET    96 = rotated_bits[13]
* NET    97 = rotated_bits[127]
* NET    98 = rotated_bits[126]
* NET    99 = rotated_bits[125]
* NET   100 = rotated_bits[124]
* NET   101 = rotated_bits[123]
* NET   102 = rotated_bits[122]
* NET   103 = rotated_bits[121]
* NET   104 = rotated_bits[120]
* NET   105 = rotated_bits[12]
* NET   106 = rotated_bits[119]
* NET   107 = rotated_bits[118]
* NET   108 = rotated_bits[117]
* NET   109 = rotated_bits[116]
* NET   110 = rotated_bits[115]
* NET   111 = rotated_bits[114]
* NET   112 = rotated_bits[113]
* NET   113 = rotated_bits[112]
* NET   114 = rotated_bits[111]
* NET   115 = rotated_bits[110]
* NET   116 = rotated_bits[11]
* NET   117 = rotated_bits[109]
* NET   118 = rotated_bits[108]
* NET   119 = rotated_bits[107]
* NET   120 = rotated_bits[106]
* NET   121 = rotated_bits[105]
* NET   122 = rotated_bits[104]
* NET   123 = rotated_bits[103]
* NET   124 = rotated_bits[102]
* NET   125 = rotated_bits[101]
* NET   126 = rotated_bits[100]
* NET   127 = rotated_bits[10]
* NET   128 = rotated_bits[1]
* NET   129 = rotated_bits[0]
* NET   130 = k[6]
* NET   131 = k[5]
* NET   132 = k[4]
* NET   133 = k[3]
* NET   134 = k[2]
* NET   135 = k[1]
* NET   136 = k[0]
* NET   137 = blockagenet
* NET   138 = bits[99]
* NET   139 = bits[98]
* NET   140 = bits[97]
* NET   141 = bits[96]
* NET   142 = bits[95]
* NET   143 = bits[94]
* NET   144 = bits[93]
* NET   145 = bits[92]
* NET   146 = bits[91]
* NET   147 = bits[90]
* NET   148 = bits[9]
* NET   149 = bits[89]
* NET   150 = bits[88]
* NET   151 = bits[87]
* NET   152 = bits[86]
* NET   153 = bits[85]
* NET   154 = bits[84]
* NET   155 = bits[83]
* NET   156 = bits[82]
* NET   157 = bits[81]
* NET   158 = bits[80]
* NET   159 = bits[8]
* NET   160 = bits[79]
* NET   161 = bits[78]
* NET   162 = bits[77]
* NET   163 = bits[76]
* NET   164 = bits[75]
* NET   165 = bits[74]
* NET   166 = bits[73]
* NET   167 = bits[72]
* NET   168 = bits[71]
* NET   169 = bits[70]
* NET   170 = bits[7]
* NET   171 = bits[69]
* NET   172 = bits[68]
* NET   173 = bits[67]
* NET   174 = bits[66]
* NET   175 = bits[65]
* NET   176 = bits[64]
* NET   177 = bits[63]
* NET   178 = bits[62]
* NET   179 = bits[61]
* NET   180 = bits[60]
* NET   181 = bits[6]
* NET   182 = bits[59]
* NET   183 = bits[58]
* NET   184 = bits[57]
* NET   185 = bits[56]
* NET   186 = bits[55]
* NET   187 = bits[54]
* NET   188 = bits[53]
* NET   189 = bits[52]
* NET   190 = bits[51]
* NET   191 = bits[50]
* NET   192 = bits[5]
* NET   193 = bits[49]
* NET   194 = bits[48]
* NET   195 = bits[47]
* NET   196 = bits[46]
* NET   197 = bits[45]
* NET   198 = bits[44]
* NET   199 = bits[43]
* NET   200 = bits[42]
* NET   201 = bits[41]
* NET   202 = bits[40]
* NET   203 = bits[4]
* NET   204 = bits[39]
* NET   205 = bits[38]
* NET   206 = bits[37]
* NET   207 = bits[36]
* NET   208 = bits[35]
* NET   209 = bits[34]
* NET   210 = bits[33]
* NET   211 = bits[32]
* NET   212 = bits[31]
* NET   213 = bits[30]
* NET   214 = bits[3]
* NET   215 = bits[29]
* NET   216 = bits[28]
* NET   217 = bits[27]
* NET   218 = bits[26]
* NET   219 = bits[25]
* NET   220 = bits[24]
* NET   221 = bits[23]
* NET   222 = bits[22]
* NET   223 = bits[21]
* NET   224 = bits[20]
* NET   225 = bits[2]
* NET   226 = bits[19]
* NET   227 = bits[18]
* NET   228 = bits[17]
* NET   229 = bits[16]
* NET   230 = bits[15]
* NET   231 = bits[14]
* NET   232 = bits[13]
* NET   233 = bits[127]
* NET   234 = bits[126]
* NET   235 = bits[125]
* NET   236 = bits[124]
* NET   237 = bits[123]
* NET   238 = bits[122]
* NET   239 = bits[121]
* NET   240 = bits[120]
* NET   241 = bits[12]
* NET   242 = bits[119]
* NET   243 = bits[118]
* NET   244 = bits[117]
* NET   245 = bits[116]
* NET   246 = bits[115]
* NET   247 = bits[114]
* NET   248 = bits[113]
* NET   249 = bits[112]
* NET   250 = bits[111]
* NET   251 = bits[110]
* NET   252 = bits[11]
* NET   253 = bits[109]
* NET   254 = bits[108]
* NET   255 = bits[107]
* NET   256 = bits[106]
* NET   257 = bits[105]
* NET   258 = bits[104]
* NET   259 = bits[103]
* NET   260 = bits[102]
* NET   261 = bits[101]
* NET   262 = bits[100]
* NET   263 = bits[10]
* NET   264 = bits[1]
* NET   265 = bits[0]
* NET   266 = abc_2923_new_n999
* NET   267 = abc_2923_new_n998
* NET   268 = abc_2923_new_n997
* NET   269 = abc_2923_new_n996
* NET   270 = abc_2923_new_n995
* NET   271 = abc_2923_new_n993
* NET   272 = abc_2923_new_n992
* NET   273 = abc_2923_new_n991
* NET   274 = abc_2923_new_n990
* NET   275 = abc_2923_new_n989
* NET   276 = abc_2923_new_n987
* NET   277 = abc_2923_new_n986
* NET   278 = abc_2923_new_n985
* NET   279 = abc_2923_new_n984
* NET   280 = abc_2923_new_n983
* NET   281 = abc_2923_new_n981
* NET   282 = abc_2923_new_n980
* NET   283 = abc_2923_new_n979
* NET   284 = abc_2923_new_n978
* NET   285 = abc_2923_new_n977
* NET   286 = abc_2923_new_n975
* NET   287 = abc_2923_new_n974
* NET   288 = abc_2923_new_n973
* NET   289 = abc_2923_new_n972
* NET   290 = abc_2923_new_n971
* NET   291 = abc_2923_new_n969
* NET   292 = abc_2923_new_n968
* NET   293 = abc_2923_new_n967
* NET   294 = abc_2923_new_n966
* NET   295 = abc_2923_new_n965
* NET   296 = abc_2923_new_n963
* NET   297 = abc_2923_new_n962
* NET   298 = abc_2923_new_n961
* NET   299 = abc_2923_new_n960
* NET   300 = abc_2923_new_n959
* NET   301 = abc_2923_new_n957
* NET   302 = abc_2923_new_n956
* NET   303 = abc_2923_new_n955
* NET   304 = abc_2923_new_n954
* NET   305 = abc_2923_new_n953
* NET   306 = abc_2923_new_n951
* NET   307 = abc_2923_new_n950
* NET   308 = abc_2923_new_n949
* NET   309 = abc_2923_new_n948
* NET   310 = abc_2923_new_n947
* NET   311 = abc_2923_new_n945
* NET   312 = abc_2923_new_n944
* NET   313 = abc_2923_new_n943
* NET   314 = abc_2923_new_n942
* NET   315 = abc_2923_new_n941
* NET   316 = abc_2923_new_n939
* NET   317 = abc_2923_new_n938
* NET   318 = abc_2923_new_n937
* NET   319 = abc_2923_new_n936
* NET   320 = abc_2923_new_n935
* NET   321 = abc_2923_new_n933
* NET   322 = abc_2923_new_n932
* NET   323 = abc_2923_new_n931
* NET   324 = abc_2923_new_n930
* NET   325 = abc_2923_new_n929
* NET   326 = abc_2923_new_n927
* NET   327 = abc_2923_new_n926
* NET   328 = abc_2923_new_n925
* NET   329 = abc_2923_new_n924
* NET   330 = abc_2923_new_n923
* NET   331 = abc_2923_new_n921
* NET   332 = abc_2923_new_n920
* NET   333 = abc_2923_new_n919
* NET   334 = abc_2923_new_n918
* NET   335 = abc_2923_new_n917
* NET   336 = abc_2923_new_n915
* NET   337 = abc_2923_new_n914
* NET   338 = abc_2923_new_n913
* NET   339 = abc_2923_new_n912
* NET   340 = abc_2923_new_n911
* NET   341 = abc_2923_new_n909
* NET   342 = abc_2923_new_n908
* NET   343 = abc_2923_new_n907
* NET   344 = abc_2923_new_n906
* NET   345 = abc_2923_new_n905
* NET   346 = abc_2923_new_n903
* NET   347 = abc_2923_new_n902
* NET   348 = abc_2923_new_n901
* NET   349 = abc_2923_new_n900
* NET   350 = abc_2923_new_n899
* NET   351 = abc_2923_new_n897
* NET   352 = abc_2923_new_n896
* NET   353 = abc_2923_new_n895
* NET   354 = abc_2923_new_n894
* NET   355 = abc_2923_new_n893
* NET   356 = abc_2923_new_n891
* NET   357 = abc_2923_new_n890
* NET   358 = abc_2923_new_n889
* NET   359 = abc_2923_new_n888
* NET   360 = abc_2923_new_n887
* NET   361 = abc_2923_new_n885
* NET   362 = abc_2923_new_n884
* NET   363 = abc_2923_new_n883
* NET   364 = abc_2923_new_n882
* NET   365 = abc_2923_new_n881
* NET   366 = abc_2923_new_n879
* NET   367 = abc_2923_new_n878
* NET   368 = abc_2923_new_n877
* NET   369 = abc_2923_new_n876
* NET   370 = abc_2923_new_n875
* NET   371 = abc_2923_new_n873
* NET   372 = abc_2923_new_n872
* NET   373 = abc_2923_new_n871
* NET   374 = abc_2923_new_n870
* NET   375 = abc_2923_new_n869
* NET   376 = abc_2923_new_n867
* NET   377 = abc_2923_new_n866
* NET   378 = abc_2923_new_n865
* NET   379 = abc_2923_new_n864
* NET   380 = abc_2923_new_n863
* NET   381 = abc_2923_new_n861
* NET   382 = abc_2923_new_n860
* NET   383 = abc_2923_new_n859
* NET   384 = abc_2923_new_n858
* NET   385 = abc_2923_new_n857
* NET   386 = abc_2923_new_n855
* NET   387 = abc_2923_new_n854
* NET   388 = abc_2923_new_n853
* NET   389 = abc_2923_new_n852
* NET   390 = abc_2923_new_n851
* NET   391 = abc_2923_new_n849
* NET   392 = abc_2923_new_n848
* NET   393 = abc_2923_new_n847
* NET   394 = abc_2923_new_n846
* NET   395 = abc_2923_new_n845
* NET   396 = abc_2923_new_n843
* NET   397 = abc_2923_new_n842
* NET   398 = abc_2923_new_n841
* NET   399 = abc_2923_new_n840
* NET   400 = abc_2923_new_n839
* NET   401 = abc_2923_new_n838
* NET   402 = abc_2923_new_n836
* NET   403 = abc_2923_new_n835
* NET   404 = abc_2923_new_n834
* NET   405 = abc_2923_new_n833
* NET   406 = abc_2923_new_n832
* NET   407 = abc_2923_new_n831
* NET   408 = abc_2923_new_n829
* NET   409 = abc_2923_new_n828
* NET   410 = abc_2923_new_n827
* NET   411 = abc_2923_new_n826
* NET   412 = abc_2923_new_n825
* NET   413 = abc_2923_new_n824
* NET   414 = abc_2923_new_n822
* NET   415 = abc_2923_new_n821
* NET   416 = abc_2923_new_n820
* NET   417 = abc_2923_new_n819
* NET   418 = abc_2923_new_n818
* NET   419 = abc_2923_new_n817
* NET   420 = abc_2923_new_n815
* NET   421 = abc_2923_new_n814
* NET   422 = abc_2923_new_n813
* NET   423 = abc_2923_new_n812
* NET   424 = abc_2923_new_n811
* NET   425 = abc_2923_new_n810
* NET   426 = abc_2923_new_n808
* NET   427 = abc_2923_new_n807
* NET   428 = abc_2923_new_n806
* NET   429 = abc_2923_new_n805
* NET   430 = abc_2923_new_n804
* NET   431 = abc_2923_new_n803
* NET   432 = abc_2923_new_n801
* NET   433 = abc_2923_new_n800
* NET   434 = abc_2923_new_n799
* NET   435 = abc_2923_new_n798
* NET   436 = abc_2923_new_n797
* NET   437 = abc_2923_new_n796
* NET   438 = abc_2923_new_n794
* NET   439 = abc_2923_new_n793
* NET   440 = abc_2923_new_n792
* NET   441 = abc_2923_new_n791
* NET   442 = abc_2923_new_n790
* NET   443 = abc_2923_new_n789
* NET   444 = abc_2923_new_n787
* NET   445 = abc_2923_new_n786
* NET   446 = abc_2923_new_n785
* NET   447 = abc_2923_new_n784
* NET   448 = abc_2923_new_n783
* NET   449 = abc_2923_new_n782
* NET   450 = abc_2923_new_n780
* NET   451 = abc_2923_new_n779
* NET   452 = abc_2923_new_n778
* NET   453 = abc_2923_new_n777
* NET   454 = abc_2923_new_n776
* NET   455 = abc_2923_new_n775
* NET   456 = abc_2923_new_n773
* NET   457 = abc_2923_new_n772
* NET   458 = abc_2923_new_n771
* NET   459 = abc_2923_new_n770
* NET   460 = abc_2923_new_n769
* NET   461 = abc_2923_new_n768
* NET   462 = abc_2923_new_n766
* NET   463 = abc_2923_new_n765
* NET   464 = abc_2923_new_n764
* NET   465 = abc_2923_new_n763
* NET   466 = abc_2923_new_n762
* NET   467 = abc_2923_new_n761
* NET   468 = abc_2923_new_n759
* NET   469 = abc_2923_new_n758
* NET   470 = abc_2923_new_n757
* NET   471 = abc_2923_new_n756
* NET   472 = abc_2923_new_n755
* NET   473 = abc_2923_new_n754
* NET   474 = abc_2923_new_n752
* NET   475 = abc_2923_new_n751
* NET   476 = abc_2923_new_n750
* NET   477 = abc_2923_new_n749
* NET   478 = abc_2923_new_n748
* NET   479 = abc_2923_new_n747
* NET   480 = abc_2923_new_n745
* NET   481 = abc_2923_new_n744
* NET   482 = abc_2923_new_n743
* NET   483 = abc_2923_new_n742
* NET   484 = abc_2923_new_n741
* NET   485 = abc_2923_new_n740
* NET   486 = abc_2923_new_n738
* NET   487 = abc_2923_new_n737
* NET   488 = abc_2923_new_n736
* NET   489 = abc_2923_new_n735
* NET   490 = abc_2923_new_n734
* NET   491 = abc_2923_new_n733
* NET   492 = abc_2923_new_n731
* NET   493 = abc_2923_new_n730
* NET   494 = abc_2923_new_n729
* NET   495 = abc_2923_new_n728
* NET   496 = abc_2923_new_n727
* NET   497 = abc_2923_new_n726
* NET   498 = abc_2923_new_n724
* NET   499 = abc_2923_new_n723
* NET   500 = abc_2923_new_n722
* NET   501 = abc_2923_new_n721
* NET   502 = abc_2923_new_n720
* NET   503 = abc_2923_new_n719
* NET   504 = abc_2923_new_n717
* NET   505 = abc_2923_new_n716
* NET   506 = abc_2923_new_n715
* NET   507 = abc_2923_new_n714
* NET   508 = abc_2923_new_n713
* NET   509 = abc_2923_new_n712
* NET   510 = abc_2923_new_n710
* NET   511 = abc_2923_new_n709
* NET   512 = abc_2923_new_n708
* NET   513 = abc_2923_new_n707
* NET   514 = abc_2923_new_n706
* NET   515 = abc_2923_new_n705
* NET   516 = abc_2923_new_n703
* NET   517 = abc_2923_new_n702
* NET   518 = abc_2923_new_n701
* NET   519 = abc_2923_new_n700
* NET   520 = abc_2923_new_n699
* NET   521 = abc_2923_new_n698
* NET   522 = abc_2923_new_n696
* NET   523 = abc_2923_new_n695
* NET   524 = abc_2923_new_n694
* NET   525 = abc_2923_new_n693
* NET   526 = abc_2923_new_n692
* NET   527 = abc_2923_new_n691
* NET   528 = abc_2923_new_n689
* NET   529 = abc_2923_new_n688
* NET   530 = abc_2923_new_n687
* NET   531 = abc_2923_new_n686
* NET   532 = abc_2923_new_n685
* NET   533 = abc_2923_new_n684
* NET   534 = abc_2923_new_n682
* NET   535 = abc_2923_new_n681
* NET   536 = abc_2923_new_n680
* NET   537 = abc_2923_new_n679
* NET   538 = abc_2923_new_n678
* NET   539 = abc_2923_new_n677
* NET   540 = abc_2923_new_n675
* NET   541 = abc_2923_new_n674
* NET   542 = abc_2923_new_n673
* NET   543 = abc_2923_new_n672
* NET   544 = abc_2923_new_n671
* NET   545 = abc_2923_new_n670
* NET   546 = abc_2923_new_n668
* NET   547 = abc_2923_new_n667
* NET   548 = abc_2923_new_n666
* NET   549 = abc_2923_new_n665
* NET   550 = abc_2923_new_n664
* NET   551 = abc_2923_new_n663
* NET   552 = abc_2923_new_n661
* NET   553 = abc_2923_new_n660
* NET   554 = abc_2923_new_n659
* NET   555 = abc_2923_new_n658
* NET   556 = abc_2923_new_n657
* NET   557 = abc_2923_new_n656
* NET   558 = abc_2923_new_n654
* NET   559 = abc_2923_new_n653
* NET   560 = abc_2923_new_n652
* NET   561 = abc_2923_new_n651
* NET   562 = abc_2923_new_n650
* NET   563 = abc_2923_new_n649
* NET   564 = abc_2923_new_n647
* NET   565 = abc_2923_new_n646
* NET   566 = abc_2923_new_n645
* NET   567 = abc_2923_new_n644
* NET   568 = abc_2923_new_n643
* NET   569 = abc_2923_new_n642
* NET   570 = abc_2923_new_n640
* NET   571 = abc_2923_new_n639
* NET   572 = abc_2923_new_n638
* NET   573 = abc_2923_new_n637
* NET   574 = abc_2923_new_n636
* NET   575 = abc_2923_new_n635
* NET   576 = abc_2923_new_n633
* NET   577 = abc_2923_new_n632
* NET   578 = abc_2923_new_n631
* NET   579 = abc_2923_new_n630
* NET   580 = abc_2923_new_n629
* NET   581 = abc_2923_new_n628
* NET   582 = abc_2923_new_n626
* NET   583 = abc_2923_new_n625
* NET   584 = abc_2923_new_n624
* NET   585 = abc_2923_new_n623
* NET   586 = abc_2923_new_n622
* NET   587 = abc_2923_new_n621
* NET   588 = abc_2923_new_n619
* NET   589 = abc_2923_new_n618
* NET   590 = abc_2923_new_n617
* NET   591 = abc_2923_new_n616
* NET   592 = abc_2923_new_n615
* NET   593 = abc_2923_new_n614
* NET   594 = abc_2923_new_n612
* NET   595 = abc_2923_new_n611
* NET   596 = abc_2923_new_n610
* NET   597 = abc_2923_new_n609
* NET   598 = abc_2923_new_n608
* NET   599 = abc_2923_new_n607
* NET   600 = abc_2923_new_n605
* NET   601 = abc_2923_new_n604
* NET   602 = abc_2923_new_n603
* NET   603 = abc_2923_new_n602
* NET   604 = abc_2923_new_n601
* NET   605 = abc_2923_new_n600
* NET   606 = abc_2923_new_n598
* NET   607 = abc_2923_new_n597
* NET   608 = abc_2923_new_n596
* NET   609 = abc_2923_new_n595
* NET   610 = abc_2923_new_n594
* NET   611 = abc_2923_new_n593
* NET   612 = abc_2923_new_n591
* NET   613 = abc_2923_new_n590
* NET   614 = abc_2923_new_n589
* NET   615 = abc_2923_new_n588
* NET   616 = abc_2923_new_n587
* NET   617 = abc_2923_new_n586
* NET   618 = abc_2923_new_n584
* NET   619 = abc_2923_new_n583
* NET   620 = abc_2923_new_n582
* NET   621 = abc_2923_new_n581
* NET   622 = abc_2923_new_n580
* NET   623 = abc_2923_new_n579
* NET   624 = abc_2923_new_n577
* NET   625 = abc_2923_new_n576
* NET   626 = abc_2923_new_n575
* NET   627 = abc_2923_new_n574
* NET   628 = abc_2923_new_n573
* NET   629 = abc_2923_new_n572
* NET   630 = abc_2923_new_n570
* NET   631 = abc_2923_new_n569
* NET   632 = abc_2923_new_n568
* NET   633 = abc_2923_new_n567
* NET   634 = abc_2923_new_n566
* NET   635 = abc_2923_new_n565
* NET   636 = abc_2923_new_n563
* NET   637 = abc_2923_new_n562
* NET   638 = abc_2923_new_n561
* NET   639 = abc_2923_new_n560
* NET   640 = abc_2923_new_n559
* NET   641 = abc_2923_new_n558
* NET   642 = abc_2923_new_n556
* NET   643 = abc_2923_new_n555
* NET   644 = abc_2923_new_n554
* NET   645 = abc_2923_new_n553
* NET   646 = abc_2923_new_n552
* NET   647 = abc_2923_new_n551
* NET   648 = abc_2923_new_n549
* NET   649 = abc_2923_new_n548
* NET   650 = abc_2923_new_n547
* NET   651 = abc_2923_new_n546
* NET   652 = abc_2923_new_n545
* NET   653 = abc_2923_new_n544
* NET   654 = abc_2923_new_n542
* NET   655 = abc_2923_new_n541
* NET   656 = abc_2923_new_n540
* NET   657 = abc_2923_new_n539
* NET   658 = abc_2923_new_n538
* NET   659 = abc_2923_new_n537
* NET   660 = abc_2923_new_n535
* NET   661 = abc_2923_new_n534
* NET   662 = abc_2923_new_n533
* NET   663 = abc_2923_new_n532
* NET   664 = abc_2923_new_n531
* NET   665 = abc_2923_new_n530
* NET   666 = abc_2923_new_n528
* NET   667 = abc_2923_new_n527
* NET   668 = abc_2923_new_n526
* NET   669 = abc_2923_new_n525
* NET   670 = abc_2923_new_n524
* NET   671 = abc_2923_new_n523
* NET   672 = abc_2923_new_n521
* NET   673 = abc_2923_new_n520
* NET   674 = abc_2923_new_n519
* NET   675 = abc_2923_new_n518
* NET   676 = abc_2923_new_n517
* NET   677 = abc_2923_new_n516
* NET   678 = abc_2923_new_n514
* NET   679 = abc_2923_new_n513
* NET   680 = abc_2923_new_n512
* NET   681 = abc_2923_new_n511
* NET   682 = abc_2923_new_n510
* NET   683 = abc_2923_new_n509
* NET   684 = abc_2923_new_n507
* NET   685 = abc_2923_new_n506
* NET   686 = abc_2923_new_n505
* NET   687 = abc_2923_new_n504
* NET   688 = abc_2923_new_n503
* NET   689 = abc_2923_new_n502
* NET   690 = abc_2923_new_n500
* NET   691 = abc_2923_new_n499
* NET   692 = abc_2923_new_n498
* NET   693 = abc_2923_new_n497
* NET   694 = abc_2923_new_n496
* NET   695 = abc_2923_new_n495
* NET   696 = abc_2923_new_n493
* NET   697 = abc_2923_new_n492
* NET   698 = abc_2923_new_n491
* NET   699 = abc_2923_new_n490
* NET   700 = abc_2923_new_n489
* NET   701 = abc_2923_new_n488
* NET   702 = abc_2923_new_n486
* NET   703 = abc_2923_new_n485
* NET   704 = abc_2923_new_n484
* NET   705 = abc_2923_new_n483
* NET   706 = abc_2923_new_n482
* NET   707 = abc_2923_new_n481
* NET   708 = abc_2923_new_n479
* NET   709 = abc_2923_new_n478
* NET   710 = abc_2923_new_n477
* NET   711 = abc_2923_new_n476
* NET   712 = abc_2923_new_n475
* NET   713 = abc_2923_new_n474
* NET   714 = abc_2923_new_n472
* NET   715 = abc_2923_new_n471
* NET   716 = abc_2923_new_n470
* NET   717 = abc_2923_new_n469
* NET   718 = abc_2923_new_n468
* NET   719 = abc_2923_new_n467
* NET   720 = abc_2923_new_n465
* NET   721 = abc_2923_new_n464
* NET   722 = abc_2923_new_n463
* NET   723 = abc_2923_new_n462
* NET   724 = abc_2923_new_n461
* NET   725 = abc_2923_new_n460
* NET   726 = abc_2923_new_n458
* NET   727 = abc_2923_new_n457
* NET   728 = abc_2923_new_n456
* NET   729 = abc_2923_new_n455
* NET   730 = abc_2923_new_n454
* NET   731 = abc_2923_new_n453
* NET   732 = abc_2923_new_n451
* NET   733 = abc_2923_new_n450
* NET   734 = abc_2923_new_n449
* NET   735 = abc_2923_new_n448
* NET   736 = abc_2923_new_n447
* NET   737 = abc_2923_new_n446
* NET   738 = abc_2923_new_n444
* NET   739 = abc_2923_new_n443
* NET   740 = abc_2923_new_n442
* NET   741 = abc_2923_new_n441
* NET   742 = abc_2923_new_n440
* NET   743 = abc_2923_new_n439
* NET   744 = abc_2923_new_n437
* NET   745 = abc_2923_new_n436
* NET   746 = abc_2923_new_n435
* NET   747 = abc_2923_new_n434
* NET   748 = abc_2923_new_n433
* NET   749 = abc_2923_new_n432
* NET   750 = abc_2923_new_n430
* NET   751 = abc_2923_new_n429
* NET   752 = abc_2923_new_n428
* NET   753 = abc_2923_new_n427
* NET   754 = abc_2923_new_n426
* NET   755 = abc_2923_new_n425
* NET   756 = abc_2923_new_n423
* NET   757 = abc_2923_new_n422
* NET   758 = abc_2923_new_n421
* NET   759 = abc_2923_new_n420
* NET   760 = abc_2923_new_n419
* NET   761 = abc_2923_new_n418
* NET   762 = abc_2923_new_n416
* NET   763 = abc_2923_new_n415
* NET   764 = abc_2923_new_n414
* NET   765 = abc_2923_new_n413
* NET   766 = abc_2923_new_n412
* NET   767 = abc_2923_new_n411
* NET   768 = abc_2923_new_n409
* NET   769 = abc_2923_new_n408
* NET   770 = abc_2923_new_n407
* NET   771 = abc_2923_new_n406
* NET   772 = abc_2923_new_n405
* NET   773 = abc_2923_new_n404
* NET   774 = abc_2923_new_n402
* NET   775 = abc_2923_new_n401
* NET   776 = abc_2923_new_n400
* NET   777 = abc_2923_new_n399
* NET   778 = abc_2923_new_n398
* NET   779 = abc_2923_new_n397
* NET   780 = abc_2923_new_n395
* NET   781 = abc_2923_new_n394
* NET   782 = abc_2923_new_n393
* NET   783 = abc_2923_new_n392
* NET   784 = abc_2923_new_n391
* NET   785 = abc_2923_new_n390
* NET   786 = abc_2923_new_n389
* NET   787 = abc_2923_new_n388
* NET   788 = abc_2923_new_n387
* NET   789 = abc_2923_new_n386
* NET   790 = abc_2923_new_n385
* NET   791 = abc_2923_new_n384
* NET   792 = abc_2923_new_n383
* NET   793 = abc_2923_new_n382
* NET   794 = abc_2923_new_n381
* NET   795 = abc_2923_new_n380
* NET   796 = abc_2923_new_n379
* NET   797 = abc_2923_new_n378
* NET   798 = abc_2923_new_n377
* NET   799 = abc_2923_new_n376
* NET   800 = abc_2923_new_n375
* NET   801 = abc_2923_new_n374
* NET   802 = abc_2923_new_n373
* NET   803 = abc_2923_new_n372
* NET   804 = abc_2923_new_n371
* NET   805 = abc_2923_new_n370
* NET   806 = abc_2923_new_n369
* NET   807 = abc_2923_new_n368
* NET   808 = abc_2923_new_n367
* NET   809 = abc_2923_new_n366
* NET   810 = abc_2923_new_n365
* NET   811 = abc_2923_new_n364
* NET   812 = abc_2923_new_n363
* NET   813 = abc_2923_new_n362
* NET   814 = abc_2923_new_n361
* NET   815 = abc_2923_new_n360
* NET   816 = abc_2923_new_n359
* NET   817 = abc_2923_new_n358
* NET   818 = abc_2923_new_n357
* NET   819 = abc_2923_new_n356
* NET   820 = abc_2923_new_n355
* NET   821 = abc_2923_new_n354
* NET   822 = abc_2923_new_n353
* NET   823 = abc_2923_new_n352
* NET   824 = abc_2923_new_n351
* NET   825 = abc_2923_new_n350
* NET   826 = abc_2923_new_n349
* NET   827 = abc_2923_new_n348
* NET   828 = abc_2923_new_n347
* NET   829 = abc_2923_new_n346
* NET   830 = abc_2923_new_n345
* NET   831 = abc_2923_new_n344
* NET   832 = abc_2923_new_n343
* NET   833 = abc_2923_new_n342
* NET   834 = abc_2923_new_n341
* NET   835 = abc_2923_new_n340
* NET   836 = abc_2923_new_n339
* NET   837 = abc_2923_new_n338
* NET   838 = abc_2923_new_n337
* NET   839 = abc_2923_new_n336
* NET   840 = abc_2923_new_n335
* NET   841 = abc_2923_new_n334
* NET   842 = abc_2923_new_n333
* NET   843 = abc_2923_new_n332
* NET   844 = abc_2923_new_n331
* NET   845 = abc_2923_new_n330
* NET   846 = abc_2923_new_n329
* NET   847 = abc_2923_new_n328
* NET   848 = abc_2923_new_n327
* NET   849 = abc_2923_new_n326
* NET   850 = abc_2923_new_n325
* NET   851 = abc_2923_new_n324
* NET   852 = abc_2923_new_n323
* NET   853 = abc_2923_new_n322
* NET   854 = abc_2923_new_n321
* NET   855 = abc_2923_new_n320
* NET   856 = abc_2923_new_n319
* NET   857 = abc_2923_new_n318
* NET   858 = abc_2923_new_n317
* NET   859 = abc_2923_new_n316
* NET   860 = abc_2923_new_n315
* NET   861 = abc_2923_new_n314
* NET   862 = abc_2923_new_n313
* NET   863 = abc_2923_new_n312
* NET   864 = abc_2923_new_n311
* NET   865 = abc_2923_new_n310
* NET   866 = abc_2923_new_n309
* NET   867 = abc_2923_new_n308
* NET   868 = abc_2923_new_n307
* NET   869 = abc_2923_new_n306
* NET   870 = abc_2923_new_n305
* NET   871 = abc_2923_new_n304
* NET   872 = abc_2923_new_n303
* NET   873 = abc_2923_new_n302
* NET   874 = abc_2923_new_n301
* NET   875 = abc_2923_new_n300
* NET   876 = abc_2923_new_n299
* NET   877 = abc_2923_new_n298
* NET   878 = abc_2923_new_n297
* NET   879 = abc_2923_new_n296
* NET   880 = abc_2923_new_n295
* NET   881 = abc_2923_new_n294
* NET   882 = abc_2923_new_n293
* NET   883 = abc_2923_new_n292
* NET   884 = abc_2923_new_n291
* NET   885 = abc_2923_new_n290
* NET   886 = abc_2923_new_n289
* NET   887 = abc_2923_new_n288
* NET   888 = abc_2923_new_n287
* NET   889 = abc_2923_new_n286
* NET   890 = abc_2923_new_n285
* NET   891 = abc_2923_new_n284
* NET   892 = abc_2923_new_n283
* NET   893 = abc_2923_new_n282
* NET   894 = abc_2923_new_n281
* NET   895 = abc_2923_new_n280
* NET   896 = abc_2923_new_n279
* NET   897 = abc_2923_new_n278
* NET   898 = abc_2923_new_n277
* NET   899 = abc_2923_new_n276
* NET   900 = abc_2923_new_n275
* NET   901 = abc_2923_new_n274
* NET   902 = abc_2923_new_n273
* NET   903 = abc_2923_new_n272
* NET   904 = abc_2923_new_n271
* NET   905 = abc_2923_new_n270
* NET   906 = abc_2923_new_n269
* NET   907 = abc_2923_new_n268
* NET   908 = abc_2923_new_n267
* NET   909 = abc_2923_new_n266
* NET   910 = abc_2923_new_n265
* NET   911 = abc_2923_new_n264
* NET   912 = abc_2923_new_n1163
* NET   913 = abc_2923_new_n1161
* NET   914 = abc_2923_new_n1159
* NET   915 = abc_2923_new_n1158
* NET   916 = abc_2923_new_n1156
* NET   917 = abc_2923_new_n1155
* NET   918 = abc_2923_new_n1153
* NET   919 = abc_2923_new_n1152
* NET   920 = abc_2923_new_n1150
* NET   921 = abc_2923_new_n1149
* NET   922 = abc_2923_new_n1147
* NET   923 = abc_2923_new_n1146
* NET   924 = abc_2923_new_n1145
* NET   925 = abc_2923_new_n1143
* NET   926 = abc_2923_new_n1142
* NET   927 = abc_2923_new_n1141
* NET   928 = abc_2923_new_n1139
* NET   929 = abc_2923_new_n1138
* NET   930 = abc_2923_new_n1137
* NET   931 = abc_2923_new_n1135
* NET   932 = abc_2923_new_n1134
* NET   933 = abc_2923_new_n1133
* NET   934 = abc_2923_new_n1131
* NET   935 = abc_2923_new_n1130
* NET   936 = abc_2923_new_n1129
* NET   937 = abc_2923_new_n1127
* NET   938 = abc_2923_new_n1126
* NET   939 = abc_2923_new_n1125
* NET   940 = abc_2923_new_n1123
* NET   941 = abc_2923_new_n1122
* NET   942 = abc_2923_new_n1121
* NET   943 = abc_2923_new_n1119
* NET   944 = abc_2923_new_n1118
* NET   945 = abc_2923_new_n1117
* NET   946 = abc_2923_new_n1115
* NET   947 = abc_2923_new_n1114
* NET   948 = abc_2923_new_n1113
* NET   949 = abc_2923_new_n1112
* NET   950 = abc_2923_new_n1110
* NET   951 = abc_2923_new_n1109
* NET   952 = abc_2923_new_n1108
* NET   953 = abc_2923_new_n1107
* NET   954 = abc_2923_new_n1105
* NET   955 = abc_2923_new_n1104
* NET   956 = abc_2923_new_n1103
* NET   957 = abc_2923_new_n1102
* NET   958 = abc_2923_new_n1100
* NET   959 = abc_2923_new_n1099
* NET   960 = abc_2923_new_n1098
* NET   961 = abc_2923_new_n1097
* NET   962 = abc_2923_new_n1095
* NET   963 = abc_2923_new_n1094
* NET   964 = abc_2923_new_n1093
* NET   965 = abc_2923_new_n1092
* NET   966 = abc_2923_new_n1090
* NET   967 = abc_2923_new_n1089
* NET   968 = abc_2923_new_n1088
* NET   969 = abc_2923_new_n1087
* NET   970 = abc_2923_new_n1085
* NET   971 = abc_2923_new_n1084
* NET   972 = abc_2923_new_n1083
* NET   973 = abc_2923_new_n1082
* NET   974 = abc_2923_new_n1080
* NET   975 = abc_2923_new_n1079
* NET   976 = abc_2923_new_n1078
* NET   977 = abc_2923_new_n1077
* NET   978 = abc_2923_new_n1075
* NET   979 = abc_2923_new_n1074
* NET   980 = abc_2923_new_n1073
* NET   981 = abc_2923_new_n1072
* NET   982 = abc_2923_new_n1070
* NET   983 = abc_2923_new_n1069
* NET   984 = abc_2923_new_n1068
* NET   985 = abc_2923_new_n1067
* NET   986 = abc_2923_new_n1065
* NET   987 = abc_2923_new_n1064
* NET   988 = abc_2923_new_n1063
* NET   989 = abc_2923_new_n1062
* NET   990 = abc_2923_new_n1060
* NET   991 = abc_2923_new_n1059
* NET   992 = abc_2923_new_n1058
* NET   993 = abc_2923_new_n1057
* NET   994 = abc_2923_new_n1055
* NET   995 = abc_2923_new_n1054
* NET   996 = abc_2923_new_n1053
* NET   997 = abc_2923_new_n1052
* NET   998 = abc_2923_new_n1050
* NET   999 = abc_2923_new_n1049
* NET  1000 = abc_2923_new_n1048
* NET  1001 = abc_2923_new_n1047
* NET  1002 = abc_2923_new_n1045
* NET  1003 = abc_2923_new_n1044
* NET  1004 = abc_2923_new_n1043
* NET  1005 = abc_2923_new_n1042
* NET  1006 = abc_2923_new_n1040
* NET  1007 = abc_2923_new_n1039
* NET  1008 = abc_2923_new_n1038
* NET  1009 = abc_2923_new_n1037
* NET  1010 = abc_2923_new_n1035
* NET  1011 = abc_2923_new_n1034
* NET  1012 = abc_2923_new_n1033
* NET  1013 = abc_2923_new_n1032
* NET  1014 = abc_2923_new_n1031
* NET  1015 = abc_2923_new_n1029
* NET  1016 = abc_2923_new_n1028
* NET  1017 = abc_2923_new_n1027
* NET  1018 = abc_2923_new_n1026
* NET  1019 = abc_2923_new_n1025
* NET  1020 = abc_2923_new_n1023
* NET  1021 = abc_2923_new_n1022
* NET  1022 = abc_2923_new_n1021
* NET  1023 = abc_2923_new_n1020
* NET  1024 = abc_2923_new_n1019
* NET  1025 = abc_2923_new_n1017
* NET  1026 = abc_2923_new_n1016
* NET  1027 = abc_2923_new_n1015
* NET  1028 = abc_2923_new_n1014
* NET  1029 = abc_2923_new_n1013
* NET  1030 = abc_2923_new_n1011
* NET  1031 = abc_2923_new_n1010
* NET  1032 = abc_2923_new_n1009
* NET  1033 = abc_2923_new_n1008
* NET  1034 = abc_2923_new_n1007
* NET  1035 = abc_2923_new_n1005
* NET  1036 = abc_2923_new_n1004
* NET  1037 = abc_2923_new_n1003
* NET  1038 = abc_2923_new_n1002
* NET  1039 = abc_2923_new_n1001

xsubckt_734_mux2_x1 1 0 268 288 132 267 mux2_x1
xsubckt_250_mux2_x1 1 0 679 691 131 678 mux2_x1
xsubckt_211_mux2_x1 1 0 713 887 135 712 mux2_x1
xsubckt_769_mux2_x1 1 0 1013 279 133 1012 mux2_x1
xsubckt_681_mux2_x1 1 0 312 322 131 311 mux2_x1
xsubckt_285_mux2_x1 1 0 649 661 131 648 mux2_x1
xsubckt_246_mux2_x1 1 0 683 789 135 682 mux2_x1
xsubckt_207_mux2_x1 1 0 716 740 132 715 mux2_x1
xsubckt_30_mux2_x1 1 0 882 883 911 881 mux2_x1
xsubckt_444_mux2_x1 1 0 513 561 133 512 mux2_x1
xsubckt_483_mux2_x1 1 0 190 246 136 479 mux2_x1
xsubckt_840_mux2_x1 1 0 956 972 132 955 mux2_x1
xsubckt_801_mux2_x1 1 0 987 995 131 986 mux2_x1
xsubckt_642_mux2_x1 1 0 345 430 134 344 mux2_x1
xsubckt_65_mux2_x1 1 0 847 850 910 846 mux2_x1
xsubckt_26_mux2_x1 1 0 886 887 911 885 mux2_x1
xsubckt_405_mux2_x1 1 0 546 552 130 68 mux2_x1
xsubckt_603_mux2_x1 1 0 377 387 131 376 mux2_x1
xsubckt_875_mux2_x1 1 0 929 935 131 928 mux2_x1
xsubckt_836_mux2_x1 1 0 959 967 131 958 mux2_x1
xsubckt_677_mux2_x1 1 0 491 788 911 315 mux2_x1
xsubckt_193_mux2_x1 1 0 728 752 132 727 mux2_x1
xsubckt_115_mux2_x1 1 0 239 184 136 796 mux2_x1
xsubckt_154_mux2_x1 1 0 203 172 136 761 mux2_x1
xsubckt_352_mux2_x1 1 0 592 688 134 591 mux2_x1
xsubckt_391_mux2_x1 1 0 558 564 130 70 mux2_x1
xsubckt_479_mux2_x1 1 0 483 531 133 482 mux2_x1
xsubckt_550_mux2_x1 1 0 422 446 132 421 mux2_x1
xsubckt_638_mux2_x1 1 0 348 368 132 347 mux2_x1
xsubckt_313_mux2_x1 1 0 625 637 131 624 mux2_x1
xsubckt_189_mux2_x1 1 0 148 166 136 731 mux2_x1
xsubckt_8_mux2_x1 1 0 904 905 911 903 mux2_x1
xsubckt_387_mux2_x1 1 0 562 658 134 561 mux2_x1
xsubckt_511_mux2_x1 1 0 186 242 136 455 mux2_x1
xsubckt_783_mux2_x1 1 0 305 815 910 1001 mux2_x1
xsubckt_744_mux2_x1 1 0 1034 340 134 1033 mux2_x1
xsubckt_309_mux2_x1 1 0 629 859 135 628 mux2_x1
xsubckt_260_mux2_x1 1 0 671 820 135 670 mux2_x1
xsubckt_221_mux2_x1 1 0 704 728 132 703 mux2_x1
xsubckt_348_mux2_x1 1 0 595 607 131 594 mux2_x1
xsubckt_507_mux2_x1 1 0 459 507 133 458 mux2_x1
xsubckt_546_mux2_x1 1 0 180 236 136 425 mux2_x1
xsubckt_585_mux2_x1 1 0 392 403 131 391 mux2_x1
xsubckt_779_mux2_x1 1 0 1005 269 133 1004 mux2_x1
xsubckt_705_mux2_x1 1 0 292 302 131 291 mux2_x1
xsubckt_295_mux2_x1 1 0 641 898 135 640 mux2_x1
xsubckt_40_mux2_x1 1 0 251 196 136 871 mux2_x1
xsubckt_850_mux2_x1 1 0 948 964 132 947 mux2_x1
xsubckt_691_mux2_x1 1 0 304 344 133 303 mux2_x1
xsubckt_652_mux2_x1 1 0 336 341 130 27 mux2_x1
xsubckt_256_mux2_x1 1 0 674 698 132 673 mux2_x1
xsubckt_217_mux2_x1 1 0 232 162 136 707 mux2_x1
xsubckt_415_mux2_x1 1 0 538 634 134 537 mux2_x1
xsubckt_454_mux2_x1 1 0 504 510 130 60 mux2_x1
xsubckt_493_mux2_x1 1 0 471 519 133 470 mux2_x1
xsubckt_613_mux2_x1 1 0 369 411 133 368 mux2_x1
xsubckt_811_mux2_x1 1 0 979 987 131 978 mux2_x1
xsubckt_687_mux2_x1 1 0 307 317 131 306 mux2_x1
xsubckt_164_mux2_x1 1 0 753 805 133 752 mux2_x1
xsubckt_75_mux2_x1 1 0 837 840 910 836 mux2_x1
xsubckt_36_mux2_x1 1 0 876 891 908 875 mux2_x1
xsubckt_489_mux2_x1 1 0 474 480 130 54 mux2_x1
xsubckt_885_mux2_x1 1 0 933 782 908 921 mux2_x1
xsubckt_846_mux2_x1 1 0 951 959 131 950 mux2_x1
xsubckt_807_mux2_x1 1 0 982 986 130 123 mux2_x1
xsubckt_648_mux2_x1 1 0 340 424 134 339 mux2_x1
xsubckt_125_mux2_x1 1 0 140 210 136 786 mux2_x1
xsubckt_323_mux2_x1 1 0 617 890 135 616 mux2_x1
xsubckt_362_mux2_x1 1 0 583 595 131 582 mux2_x1
xsubckt_521_mux2_x1 1 0 447 495 133 446 mux2_x1
xsubckt_560_mux2_x1 1 0 178 234 136 413 mux2_x1
xsubckt_609_mux2_x1 1 0 372 382 131 371 mux2_x1
xsubckt_793_mux2_x1 1 0 295 799 910 993 mux2_x1
xsubckt_199_mux2_x1 1 0 723 771 133 722 mux2_x1
xsubckt_358_mux2_x1 1 0 587 779 135 586 mux2_x1
xsubckt_397_mux2_x1 1 0 553 565 131 552 mux2_x1
xsubckt_595_mux2_x1 1 0 384 429 133 383 mux2_x1
xsubckt_754_mux2_x1 1 0 1025 1030 130 8 mux2_x1
xsubckt_715_mux2_x1 1 0 284 324 133 283 mux2_x1
xsubckt_319_mux2_x1 1 0 620 644 132 619 mux2_x1
xsubckt_270_mux2_x1 1 0 662 686 132 661 mux2_x1
xsubckt_231_mux2_x1 1 0 230 160 136 695 mux2_x1
xsubckt_517_mux2_x1 1 0 450 456 130 50 mux2_x1
xsubckt_556_mux2_x1 1 0 417 465 133 416 mux2_x1
xsubckt_789_mux2_x1 1 0 997 1033 133 996 mux2_x1
xsubckt_266_mux2_x1 1 0 224 154 136 665 mux2_x1
xsubckt_227_mux2_x1 1 0 699 747 133 698 mux2_x1
xsubckt_50_mux2_x1 1 0 862 865 910 861 mux2_x1
xsubckt_11_mux2_x1 1 0 901 902 911 900 mux2_x1
xsubckt_464_mux2_x1 1 0 496 592 134 495 mux2_x1
xsubckt_860_mux2_x1 1 0 940 943 130 111 mux2_x1
xsubckt_821_mux2_x1 1 0 971 979 131 970 mux2_x1
xsubckt_662_mux2_x1 1 0 328 348 132 327 mux2_x1
xsubckt_46_mux2_x1 1 0 866 867 911 865 mux2_x1
xsubckt_85_mux2_x1 1 0 146 217 136 826 mux2_x1
xsubckt_100_mux2_x1 1 0 235 179 136 811 mux2_x1
xsubckt_425_mux2_x1 1 0 529 541 131 528 mux2_x1
xsubckt_623_mux2_x1 1 0 545 894 911 360 mux2_x1
xsubckt_895_mux2_x1 1 0 915 919 131 914 mux2_x1
xsubckt_856_mux2_x1 1 0 943 946 130 112 mux2_x1
xsubckt_697_mux2_x1 1 0 299 339 133 298 mux2_x1
xsubckt_658_mux2_x1 1 0 331 336 130 26 mux2_x1
xsubckt_174_mux2_x1 1 0 744 750 130 45 mux2_x1
xsubckt_135_mux2_x1 1 0 778 787 134 777 mux2_x1
xsubckt_372_mux2_x1 1 0 575 767 135 574 mux2_x1
xsubckt_499_mux2_x1 1 0 466 562 134 465 mux2_x1
xsubckt_817_mux2_x1 1 0 974 978 130 121 mux2_x1
xsubckt_333_mux2_x1 1 0 608 632 132 607 mux2_x1
xsubckt_531_mux2_x1 1 0 438 444 130 48 mux2_x1
xsubckt_570_mux2_x1 1 0 405 453 133 404 mux2_x1
xsubckt_619_mux2_x1 1 0 364 405 133 363 mux2_x1
xsubckt_764_mux2_x1 1 0 1017 1037 132 1016 mux2_x1
xsubckt_280_mux2_x1 1 0 222 152 136 653 mux2_x1
xsubckt_241_mux2_x1 1 0 687 735 133 686 mux2_x1
xsubckt_329_mux2_x1 1 0 215 144 136 611 mux2_x1
xsubckt_368_mux2_x1 1 0 578 602 132 577 mux2_x1
xsubckt_527_mux2_x1 1 0 442 538 134 441 mux2_x1
xsubckt_566_mux2_x1 1 0 408 414 130 42 mux2_x1
xsubckt_725_mux2_x1 1 0 443 795 911 275 mux2_x1
xsubckt_202_mux2_x1 1 0 720 726 130 127 mux2_x1
xsubckt_60_mux2_x1 1 0 156 227 136 851 mux2_x1
xsubckt_0_inv_x0 1 0 135 911 inv_x0
xsubckt_1_inv_x0 1 0 134 910 inv_x0
xsubckt_2_inv_x0 1 0 133 909 inv_x0
xsubckt_3_inv_x0 1 0 132 908 inv_x0
xsubckt_4_inv_x0 1 0 131 907 inv_x0
xsubckt_400_mux2_x1 1 0 551 743 135 550 mux2_x1
xsubckt_870_mux2_x1 1 0 933 945 132 932 mux2_x1
xsubckt_799_mux2_x1 1 0 989 1023 133 988 mux2_x1
xsubckt_672_mux2_x1 1 0 320 400 134 319 mux2_x1
xsubckt_276_mux2_x1 1 0 657 705 133 656 mux2_x1
xsubckt_237_mux2_x1 1 0 690 696 130 94 mux2_x1
xsubckt_5_inv_x0 1 0 130 906 inv_x0
xsubckt_21_mux2_x1 1 0 236 180 136 890 mux2_x1
xsubckt_435_mux2_x1 1 0 521 713 135 520 mux2_x1
xsubckt_474_mux2_x1 1 0 487 499 131 486 mux2_x1
xsubckt_831_mux2_x1 1 0 963 971 131 962 mux2_x1
xsubckt_56_mux2_x1 1 0 165 263 136 855 mux2_x1
xsubckt_17_mux2_x1 1 0 167 159 136 894 mux2_x1
xsubckt_95_mux2_x1 1 0 173 214 136 816 mux2_x1
xsubckt_110_mux2_x1 1 0 261 206 136 801 mux2_x1
xsubckt_633_mux2_x1 1 0 352 362 131 351 mux2_x1
xsubckt_866_mux2_x1 1 0 936 948 132 935 mux2_x1
xsubckt_827_mux2_x1 1 0 966 970 130 119 mux2_x1
xsubckt_668_mux2_x1 1 0 323 343 132 322 mux2_x1
xsubckt_304_mux2_x1 1 0 633 681 133 632 mux2_x1
xsubckt_184_mux2_x1 1 0 736 896 134 735 mux2_x1
xsubckt_106_mux2_x1 1 0 806 809 910 805 mux2_x1
xsubckt_145_mux2_x1 1 0 769 875 131 768 mux2_x1
xsubckt_343_mux2_x1 1 0 212 142 136 599 mux2_x1
xsubckt_382_mux2_x1 1 0 566 590 132 565 mux2_x1
xsubckt_541_mux2_x1 1 0 430 526 134 429 mux2_x1
xsubckt_580_mux2_x1 1 0 396 402 130 40 mux2_x1
xsubckt_629_mux2_x1 1 0 539 792 911 355 mux2_x1
xsubckt_700_mux2_x1 1 0 296 301 130 18 mux2_x1
xsubckt_378_mux2_x1 1 0 207 262 136 569 mux2_x1
xsubckt_502_mux2_x1 1 0 463 475 131 462 mux2_x1
xsubckt_774_mux2_x1 1 0 1009 274 133 1008 mux2_x1
xsubckt_735_mux2_x1 1 0 267 277 131 266 mux2_x1
xsubckt_290_mux2_x1 1 0 645 693 133 644 mux2_x1
xsubckt_251_mux2_x1 1 0 678 684 130 92 mux2_x1
xsubckt_212_mux2_x1 1 0 712 888 134 711 mux2_x1
xsubckt_339_mux2_x1 1 0 603 651 133 602 mux2_x1
xsubckt_537_mux2_x1 1 0 433 445 131 432 mux2_x1
xsubckt_576_mux2_x1 1 0 400 496 134 399 mux2_x1
xsubckt_286_mux2_x1 1 0 648 654 130 86 mux2_x1
xsubckt_70_mux2_x1 1 0 142 212 136 841 mux2_x1
xsubckt_31_mux2_x1 1 0 262 207 136 880 mux2_x1
xsubckt_410_mux2_x1 1 0 542 566 132 541 mux2_x1
xsubckt_880_mux2_x1 1 0 925 928 130 106 mux2_x1
xsubckt_841_mux2_x1 1 0 955 963 131 954 mux2_x1
xsubckt_682_mux2_x1 1 0 311 316 130 21 mux2_x1
xsubckt_643_mux2_x1 1 0 344 384 133 343 mux2_x1
xsubckt_247_mux2_x1 1 0 682 778 134 681 mux2_x1
xsubckt_208_mux2_x1 1 0 715 727 131 714 mux2_x1
xsubckt_120_mux2_x1 1 0 792 793 911 791 mux2_x1
xsubckt_406_mux2_x1 1 0 202 258 136 545 mux2_x1
xsubckt_445_mux2_x1 1 0 512 536 132 511 mux2_x1
xsubckt_484_mux2_x1 1 0 479 671 135 478 mux2_x1
xsubckt_604_mux2_x1 1 0 376 381 130 36 mux2_x1
xsubckt_802_mux2_x1 1 0 986 990 130 124 mux2_x1
xsubckt_678_mux2_x1 1 0 315 395 134 314 mux2_x1
xsubckt_194_mux2_x1 1 0 727 739 131 726 mux2_x1
xsubckt_66_mux2_x1 1 0 846 853 909 845 mux2_x1
xsubckt_27_mux2_x1 1 0 885 888 910 884 mux2_x1
xsubckt_155_mux2_x1 1 0 761 880 135 760 mux2_x1
xsubckt_392_mux2_x1 1 0 205 260 136 557 mux2_x1
xsubckt_876_mux2_x1 1 0 928 931 130 107 mux2_x1
xsubckt_837_mux2_x1 1 0 958 962 130 117 mux2_x1
xsubckt_314_mux2_x1 1 0 624 630 130 82 mux2_x1
xsubckt_9_mux2_x1 1 0 249 194 136 902 mux2_x1
xsubckt_116_mux2_x1 1 0 149 219 136 795 mux2_x1
xsubckt_353_mux2_x1 1 0 591 639 133 590 mux2_x1
xsubckt_512_mux2_x1 1 0 455 647 135 454 mux2_x1
xsubckt_551_mux2_x1 1 0 421 433 131 420 mux2_x1
xsubckt_590_mux2_x1 1 0 388 410 132 387 mux2_x1
xsubckt_639_mux2_x1 1 0 347 357 131 346 mux2_x1
xsubckt_784_mux2_x1 1 0 1001 1038 133 1000 mux2_x1
xsubckt_710_mux2_x1 1 0 288 308 132 287 mux2_x1
xsubckt_349_mux2_x1 1 0 594 600 130 76 mux2_x1
xsubckt_388_mux2_x1 1 0 561 609 133 560 mux2_x1
xsubckt_586_mux2_x1 1 0 391 396 130 39 mux2_x1
xsubckt_745_mux2_x1 1 0 1033 299 133 1032 mux2_x1
xsubckt_706_mux2_x1 1 0 291 296 130 17 mux2_x1
xsubckt_261_mux2_x1 1 0 670 766 134 669 mux2_x1
xsubckt_222_mux2_x1 1 0 703 715 131 702 mux2_x1
xsubckt_420_mux2_x1 1 0 200 256 136 533 mux2_x1
xsubckt_508_mux2_x1 1 0 458 482 132 457 mux2_x1
xsubckt_547_mux2_x1 1 0 425 617 135 424 mux2_x1
xsubckt_692_mux2_x1 1 0 303 323 132 302 mux2_x1
xsubckt_296_mux2_x1 1 0 640 736 134 639 mux2_x1
xsubckt_257_mux2_x1 1 0 673 685 131 672 mux2_x1
xsubckt_218_mux2_x1 1 0 707 808 135 706 mux2_x1
xsubckt_80_mux2_x1 1 0 168 170 136 831 mux2_x1
xsubckt_41_mux2_x1 1 0 161 231 136 870 mux2_x1
xsubckt_455_mux2_x1 1 0 195 250 136 503 mux2_x1
xsubckt_494_mux2_x1 1 0 470 494 132 469 mux2_x1
xsubckt_890_mux2_x1 1 0 918 920 130 102 mux2_x1
xsubckt_851_mux2_x1 1 0 947 955 131 946 mux2_x1
xsubckt_812_mux2_x1 1 0 978 982 130 122 mux2_x1
xsubckt_653_mux2_x1 1 0 515 807 911 335 mux2_x1
xsubckt_76_mux2_x1 1 0 242 186 136 835 mux2_x1
xsubckt_37_mux2_x1 1 0 234 178 136 874 mux2_x1
xsubckt_130_mux2_x1 1 0 782 797 908 781 mux2_x1
xsubckt_416_mux2_x1 1 0 537 585 133 536 mux2_x1
xsubckt_614_mux2_x1 1 0 368 388 132 367 mux2_x1
xsubckt_886_mux2_x1 1 0 921 926 131 920 mux2_x1
xsubckt_847_mux2_x1 1 0 950 954 130 114 mux2_x1
xsubckt_688_mux2_x1 1 0 306 311 130 20 mux2_x1
xsubckt_649_mux2_x1 1 0 339 379 133 338 mux2_x1
xsubckt_165_mux2_x1 1 0 752 776 132 751 mux2_x1
xsubckt_126_mux2_x1 1 0 175 264 136 785 mux2_x1
xsubckt_363_mux2_x1 1 0 582 588 130 74 mux2_x1
xsubckt_808_mux2_x1 1 0 280 893 910 981 mux2_x1
xsubckt_720_mux2_x1 1 0 280 360 134 279 mux2_x1
xsubckt_324_mux2_x1 1 0 616 712 134 615 mux2_x1
xsubckt_398_mux2_x1 1 0 552 558 130 69 mux2_x1
xsubckt_522_mux2_x1 1 0 446 470 132 445 mux2_x1
xsubckt_561_mux2_x1 1 0 413 605 135 412 mux2_x1
xsubckt_794_mux2_x1 1 0 993 1028 133 992 mux2_x1
xsubckt_755_mux2_x1 1 0 413 873 911 1024 mux2_x1
xsubckt_271_mux2_x1 1 0 661 673 131 660 mux2_x1
xsubckt_232_mux2_x1 1 0 695 839 135 694 mux2_x1
xsubckt_359_mux2_x1 1 0 586 682 134 585 mux2_x1
xsubckt_518_mux2_x1 1 0 185 240 136 449 mux2_x1
xsubckt_557_mux2_x1 1 0 416 440 132 415 mux2_x1
xsubckt_596_mux2_x1 1 0 383 404 132 382 mux2_x1
xsubckt_716_mux2_x1 1 0 283 303 132 282 mux2_x1
xsubckt_51_mux2_x1 1 0 861 868 909 860 mux2_x1
xsubckt_90_mux2_x1 1 0 822 825 910 821 mux2_x1
xsubckt_430_mux2_x1 1 0 525 573 133 524 mux2_x1
xsubckt_861_mux2_x1 1 0 969 814 909 939 mux2_x1
xsubckt_663_mux2_x1 1 0 327 337 131 326 mux2_x1
xsubckt_267_mux2_x1 1 0 665 883 135 664 mux2_x1
xsubckt_228_mux2_x1 1 0 698 722 132 697 mux2_x1
xsubckt_12_mux2_x1 1 0 900 903 910 899 mux2_x1
xsubckt_140_mux2_x1 1 0 225 174 136 773 mux2_x1
xsubckt_426_mux2_x1 1 0 528 534 130 64 mux2_x1
xsubckt_465_mux2_x1 1 0 495 543 133 494 mux2_x1
xsubckt_822_mux2_x1 1 0 970 974 130 120 mux2_x1
xsubckt_698_mux2_x1 1 0 298 318 132 297 mux2_x1
xsubckt_47_mux2_x1 1 0 260 205 136 864 mux2_x1
xsubckt_86_mux2_x1 1 0 826 827 911 825 mux2_x1
xsubckt_101_mux2_x1 1 0 144 215 136 810 mux2_x1
xsubckt_624_mux2_x1 1 0 360 448 134 359 mux2_x1
xsubckt_896_mux2_x1 1 0 914 916 130 100 mux2_x1
xsubckt_857_mux2_x1 1 0 973 846 909 942 mux2_x1
xsubckt_818_mux2_x1 1 0 270 854 910 973 mux2_x1
xsubckt_659_mux2_x1 1 0 509 870 911 330 mux2_x1
xsubckt_175_mux2_x1 1 0 170 168 136 743 mux2_x1
xsubckt_136_mux2_x1 1 0 777 790 133 776 mux2_x1
xsubckt_334_mux2_x1 1 0 607 619 131 606 mux2_x1
xsubckt_373_mux2_x1 1 0 574 670 134 573 mux2_x1
xsubckt_532_mux2_x1 1 0 183 238 136 437 mux2_x1
xsubckt_571_mux2_x1 1 0 404 428 132 403 mux2_x1
xsubckt_730_mux2_x1 1 0 271 276 130 13 mux2_x1
xsubckt_369_mux2_x1 1 0 577 589 131 576 mux2_x1
xsubckt_765_mux2_x1 1 0 1016 1026 131 1015 mux2_x1
xsubckt_726_mux2_x1 1 0 275 355 134 274 mux2_x1
xsubckt_281_mux2_x1 1 0 653 867 135 652 mux2_x1
xsubckt_242_mux2_x1 1 0 686 710 132 685 mux2_x1
xsubckt_203_mux2_x1 1 0 252 164 136 719 mux2_x1
xsubckt_440_mux2_x1 1 0 516 522 130 62 mux2_x1
xsubckt_528_mux2_x1 1 0 441 489 133 440 mux2_x1
xsubckt_567_mux2_x1 1 0 177 233 136 407 mux2_x1
xsubckt_277_mux2_x1 1 0 656 680 132 655 mux2_x1
xsubckt_61_mux2_x1 1 0 851 852 911 850 mux2_x1
xsubckt_22_mux2_x1 1 0 145 216 136 889 mux2_x1
xsubckt_401_mux2_x1 1 0 550 646 134 549 mux2_x1
xsubckt_475_mux2_x1 1 0 486 492 130 57 mux2_x1
xsubckt_871_mux2_x1 1 0 932 938 131 931 mux2_x1
xsubckt_832_mux2_x1 1 0 962 966 130 118 mux2_x1
xsubckt_673_mux2_x1 1 0 319 359 133 318 mux2_x1
xsubckt_238_mux2_x1 1 0 229 158 136 689 mux2_x1
xsubckt_96_mux2_x1 1 0 816 817 911 815 mux2_x1
xsubckt_111_mux2_x1 1 0 171 192 136 800 mux2_x1
xsubckt_150_mux2_x1 1 0 765 821 133 764 mux2_x1
xsubckt_436_mux2_x1 1 0 520 616 134 519 mux2_x1
xsubckt_634_mux2_x1 1 0 351 356 130 30 mux2_x1
xsubckt_669_mux2_x1 1 0 322 332 131 321 mux2_x1
xsubckt_185_mux2_x1 1 0 735 899 133 734 mux2_x1
xsubckt_57_mux2_x1 1 0 855 856 911 854 mux2_x1
xsubckt_18_mux2_x1 1 0 894 895 911 893 mux2_x1
xsubckt_146_mux2_x1 1 0 768 774 130 89 mux2_x1
xsubckt_383_mux2_x1 1 0 565 577 131 564 mux2_x1
xsubckt_867_mux2_x1 1 0 935 941 131 934 mux2_x1
xsubckt_828_mux2_x1 1 0 1034 885 910 965 mux2_x1
xsubckt_740_mux2_x1 1 0 1037 283 132 1036 mux2_x1
xsubckt_305_mux2_x1 1 0 632 656 132 631 mux2_x1
xsubckt_107_mux2_x1 1 0 244 188 136 804 mux2_x1
xsubckt_344_mux2_x1 1 0 599 842 135 598 mux2_x1
xsubckt_503_mux2_x1 1 0 462 468 130 52 mux2_x1
xsubckt_542_mux2_x1 1 0 429 477 133 428 mux2_x1
xsubckt_581_mux2_x1 1 0 587 785 911 395 mux2_x1
xsubckt_775_mux2_x1 1 0 1008 1027 132 1007 mux2_x1
xsubckt_701_mux2_x1 1 0 467 803 911 295 mux2_x1
xsubckt_291_mux2_x1 1 0 644 668 132 643 mux2_x1
xsubckt_379_mux2_x1 1 0 569 761 135 568 mux2_x1
xsubckt_538_mux2_x1 1 0 432 438 130 47 mux2_x1
xsubckt_577_mux2_x1 1 0 399 447 133 398 mux2_x1
xsubckt_736_mux2_x1 1 0 266 271 130 11 mux2_x1
xsubckt_252_mux2_x1 1 0 227 156 136 677 mux2_x1
xsubckt_213_mux2_x1 1 0 711 759 133 710 mux2_x1
xsubckt_411_mux2_x1 1 0 541 553 131 540 mux2_x1
xsubckt_450_mux2_x1 1 0 508 604 134 507 mux2_x1
xsubckt_683_mux2_x1 1 0 485 851 911 310 mux2_x1
xsubckt_287_mux2_x1 1 0 221 151 136 647 mux2_x1
xsubckt_248_mux2_x1 1 0 681 729 133 680 mux2_x1
xsubckt_209_mux2_x1 1 0 714 720 130 116 mux2_x1
xsubckt_71_mux2_x1 1 0 841 842 911 840 mux2_x1
xsubckt_32_mux2_x1 1 0 172 203 136 879 mux2_x1
xsubckt_160_mux2_x1 1 0 756 762 130 67 mux2_x1
xsubckt_446_mux2_x1 1 0 511 523 131 510 mux2_x1
xsubckt_485_mux2_x1 1 0 478 574 134 477 mux2_x1
xsubckt_881_mux2_x1 1 0 949 892 909 924 mux2_x1
xsubckt_842_mux2_x1 1 0 954 958 130 115 mux2_x1
xsubckt_803_mux2_x1 1 0 285 830 910 985 mux2_x1
xsubckt_644_mux2_x1 1 0 343 363 132 342 mux2_x1
xsubckt_67_mux2_x1 1 0 845 860 908 844 mux2_x1
xsubckt_28_mux2_x1 1 0 245 189 136 883 mux2_x1
xsubckt_121_mux2_x1 1 0 791 794 910 790 mux2_x1
xsubckt_407_mux2_x1 1 0 545 737 135 544 mux2_x1
xsubckt_605_mux2_x1 1 0 563 800 911 375 mux2_x1
xsubckt_877_mux2_x1 1 0 953 829 909 927 mux2_x1
xsubckt_838_mux2_x1 1 0 1024 869 910 957 mux2_x1
xsubckt_679_mux2_x1 1 0 314 354 133 313 mux2_x1
xsubckt_195_mux2_x1 1 0 726 732 130 12 mux2_x1
xsubckt_117_mux2_x1 1 0 795 796 911 794 mux2_x1
xsubckt_156_mux2_x1 1 0 760 881 134 759 mux2_x1
xsubckt_354_mux2_x1 1 0 590 614 132 589 mux2_x1
xsubckt_393_mux2_x1 1 0 557 749 135 556 mux2_x1
xsubckt_552_mux2_x1 1 0 420 426 130 44 mux2_x1
xsubckt_591_mux2_x1 1 0 387 397 131 386 mux2_x1
xsubckt_750_mux2_x1 1 0 1029 335 134 1028 mux2_x1
xsubckt_711_mux2_x1 1 0 287 297 131 286 mux2_x1
xsubckt_315_mux2_x1 1 0 217 146 136 623 mux2_x1
xsubckt_389_mux2_x1 1 0 560 584 132 559 mux2_x1
xsubckt_513_mux2_x1 1 0 454 550 134 453 mux2_x1
xsubckt_785_mux2_x1 1 0 1000 1017 132 999 mux2_x1
xsubckt_746_mux2_x1 1 0 1032 278 132 1031 mux2_x1
xsubckt_262_mux2_x1 1 0 669 717 133 668 mux2_x1
xsubckt_223_mux2_x1 1 0 702 708 130 96 mux2_x1
xsubckt_460_mux2_x1 1 0 499 511 131 498 mux2_x1
xsubckt_509_mux2_x1 1 0 457 469 131 456 mux2_x1
xsubckt_548_mux2_x1 1 0 424 520 134 423 mux2_x1
xsubckt_587_mux2_x1 1 0 581 848 911 390 mux2_x1
xsubckt_707_mux2_x1 1 0 461 866 911 290 mux2_x1
xsubckt_297_mux2_x1 1 0 639 687 133 638 mux2_x1
xsubckt_42_mux2_x1 1 0 870 871 911 869 mux2_x1
xsubckt_81_mux2_x1 1 0 831 832 911 830 mux2_x1
xsubckt_421_mux2_x1 1 0 533 725 135 532 mux2_x1
xsubckt_891_mux2_x1 1 0 927 813 908 917 mux2_x1
xsubckt_852_mux2_x1 1 0 946 950 130 113 mux2_x1
xsubckt_693_mux2_x1 1 0 302 312 131 301 mux2_x1
xsubckt_654_mux2_x1 1 0 335 418 134 334 mux2_x1
xsubckt_258_mux2_x1 1 0 672 678 130 91 mux2_x1
xsubckt_219_mux2_x1 1 0 706 809 134 705 mux2_x1
xsubckt_170_mux2_x1 1 0 748 865 134 747 mux2_x1
xsubckt_131_mux2_x1 1 0 781 812 907 780 mux2_x1
xsubckt_417_mux2_x1 1 0 536 560 132 535 mux2_x1
xsubckt_456_mux2_x1 1 0 503 695 135 502 mux2_x1
xsubckt_495_mux2_x1 1 0 469 481 131 468 mux2_x1
xsubckt_615_mux2_x1 1 0 367 377 131 366 mux2_x1
xsubckt_813_mux2_x1 1 0 275 791 910 977 mux2_x1
xsubckt_689_mux2_x1 1 0 479 819 911 305 mux2_x1
xsubckt_77_mux2_x1 1 0 151 221 136 834 mux2_x1
xsubckt_38_mux2_x1 1 0 143 213 136 873 mux2_x1
xsubckt_887_mux2_x1 1 0 920 922 130 103 mux2_x1
xsubckt_848_mux2_x1 1 0 1014 900 910 949 mux2_x1
xsubckt_809_mux2_x1 1 0 981 1013 133 980 mux2_x1
xsubckt_760_mux2_x1 1 0 1020 1025 130 7 mux2_x1
xsubckt_166_mux2_x1 1 0 751 763 131 750 mux2_x1
xsubckt_127_mux2_x1 1 0 785 786 911 784 mux2_x1
xsubckt_325_mux2_x1 1 0 615 663 133 614 mux2_x1
xsubckt_364_mux2_x1 1 0 209 139 136 581 mux2_x1
xsubckt_523_mux2_x1 1 0 445 457 131 444 mux2_x1
xsubckt_562_mux2_x1 1 0 412 508 134 411 mux2_x1
xsubckt_795_mux2_x1 1 0 992 1008 132 991 mux2_x1
xsubckt_721_mux2_x1 1 0 279 319 133 278 mux2_x1
xsubckt_399_mux2_x1 1 0 204 259 136 551 mux2_x1
xsubckt_597_mux2_x1 1 0 382 392 131 381 mux2_x1
xsubckt_756_mux2_x1 1 0 1024 330 134 1023 mux2_x1
xsubckt_717_mux2_x1 1 0 282 292 131 281 mux2_x1
xsubckt_272_mux2_x1 1 0 660 666 130 88 mux2_x1
xsubckt_233_mux2_x1 1 0 694 840 134 693 mux2_x1
xsubckt_431_mux2_x1 1 0 524 548 132 523 mux2_x1
xsubckt_470_mux2_x1 1 0 491 683 135 490 mux2_x1
xsubckt_519_mux2_x1 1 0 449 641 135 448 mux2_x1
xsubckt_558_mux2_x1 1 0 415 427 131 414 mux2_x1
xsubckt_268_mux2_x1 1 0 664 760 134 663 mux2_x1
xsubckt_52_mux2_x1 1 0 238 183 136 859 mux2_x1
xsubckt_13_mux2_x1 1 0 240 185 136 898 mux2_x1
xsubckt_91_mux2_x1 1 0 246 190 136 820 mux2_x1
xsubckt_466_mux2_x1 1 0 494 518 132 493 mux2_x1
xsubckt_862_mux2_x1 1 0 939 952 132 938 mux2_x1
xsubckt_823_mux2_x1 1 0 1039 822 910 969 mux2_x1
xsubckt_664_mux2_x1 1 0 326 331 130 25 mux2_x1
xsubckt_300_mux2_x1 1 0 636 642 130 84 mux2_x1
xsubckt_229_mux2_x1 1 0 697 709 131 696 mux2_x1
xsubckt_180_mux2_x1 1 0 739 751 131 738 mux2_x1
xsubckt_48_mux2_x1 1 0 169 181 136 863 mux2_x1
xsubckt_87_mux2_x1 1 0 255 199 136 824 mux2_x1
xsubckt_102_mux2_x1 1 0 810 811 911 809 mux2_x1
xsubckt_141_mux2_x1 1 0 773 849 135 772 mux2_x1
xsubckt_427_mux2_x1 1 0 199 255 136 527 mux2_x1
xsubckt_625_mux2_x1 1 0 359 399 133 358 mux2_x1
xsubckt_897_mux2_x1 1 0 917 781 907 913 mux2_x1
xsubckt_858_mux2_x1 1 0 942 956 132 941 mux2_x1
xsubckt_699_mux2_x1 1 0 297 307 131 296 mux2_x1
xsubckt_176_mux2_x1 1 0 743 832 135 742 mux2_x1
xsubckt_137_mux2_x1 1 0 776 797 132 775 mux2_x1
xsubckt_374_mux2_x1 1 0 573 621 133 572 mux2_x1
xsubckt_819_mux2_x1 1 0 973 1005 133 972 mux2_x1
xsubckt_770_mux2_x1 1 0 1012 1032 132 1011 mux2_x1
xsubckt_731_mux2_x1 1 0 437 858 911 270 mux2_x1
xsubckt_335_mux2_x1 1 0 606 612 130 79 mux2_x1
xsubckt_533_mux2_x1 1 0 437 629 135 436 mux2_x1
xsubckt_572_mux2_x1 1 0 403 415 131 402 mux2_x1
xsubckt_766_mux2_x1 1 0 1015 1020 130 6 mux2_x1
xsubckt_282_mux2_x1 1 0 652 748 134 651 mux2_x1
xsubckt_480_mux2_x1 1 0 482 506 132 481 mux2_x1
xsubckt_529_mux2_x1 1 0 440 464 132 439 mux2_x1
xsubckt_568_mux2_x1 1 0 407 599 135 406 mux2_x1
xsubckt_727_mux2_x1 1 0 274 314 133 273 mux2_x1
xsubckt_243_mux2_x1 1 0 685 697 131 684 mux2_x1
xsubckt_204_mux2_x1 1 0 719 824 135 718 mux2_x1
xsubckt_62_mux2_x1 1 0 139 209 136 849 mux2_x1
xsubckt_402_mux2_x1 1 0 549 597 133 548 mux2_x1
xsubckt_441_mux2_x1 1 0 197 253 136 515 mux2_x1
xsubckt_600_mux2_x1 1 0 380 472 134 379 mux2_x1
xsubckt_872_mux2_x1 1 0 931 934 130 108 mux2_x1
xsubckt_674_mux2_x1 1 0 318 338 132 317 mux2_x1
xsubckt_278_mux2_x1 1 0 655 667 131 654 mux2_x1
xsubckt_239_mux2_x1 1 0 689 902 135 688 mux2_x1
xsubckt_190_mux2_x1 1 0 731 793 135 730 mux2_x1
xsubckt_23_mux2_x1 1 0 889 890 911 888 mux2_x1
xsubckt_151_mux2_x1 1 0 764 828 132 763 mux2_x1
xsubckt_437_mux2_x1 1 0 519 567 133 518 mux2_x1
xsubckt_476_mux2_x1 1 0 191 247 136 485 mux2_x1
xsubckt_833_mux2_x1 1 0 1029 806 910 961 mux2_x1
xsubckt_310_mux2_x1 1 0 628 724 134 627 mux2_x1
xsubckt_58_mux2_x1 1 0 854 857 910 853 mux2_x1
xsubckt_19_mux2_x1 1 0 893 896 910 892 mux2_x1
xsubckt_97_mux2_x1 1 0 815 818 910 814 mux2_x1
xsubckt_112_mux2_x1 1 0 800 801 911 799 mux2_x1
xsubckt_635_mux2_x1 1 0 533 855 911 350 mux2_x1
xsubckt_868_mux2_x1 1 0 934 937 130 109 mux2_x1
xsubckt_829_mux2_x1 1 0 965 997 133 964 mux2_x1
xsubckt_780_mux2_x1 1 0 1004 1022 132 1003 mux2_x1
xsubckt_186_mux2_x1 1 0 734 758 132 733 mux2_x1
xsubckt_108_mux2_x1 1 0 153 223 136 803 mux2_x1
xsubckt_147_mux2_x1 1 0 214 173 136 767 mux2_x1
xsubckt_345_mux2_x1 1 0 598 694 134 597 mux2_x1
xsubckt_384_mux2_x1 1 0 564 570 130 71 mux2_x1
xsubckt_543_mux2_x1 1 0 428 452 132 427 mux2_x1
xsubckt_582_mux2_x1 1 0 395 490 134 394 mux2_x1
xsubckt_900_mux2_x1 1 0 912 913 130 98 mux2_x1
xsubckt_741_mux2_x1 1 0 1036 272 131 1035 mux2_x1
xsubckt_702_mux2_x1 1 0 295 375 134 294 mux2_x1
xsubckt_306_mux2_x1 1 0 631 643 131 630 mux2_x1
xsubckt_504_mux2_x1 1 0 187 243 136 461 mux2_x1
xsubckt_776_mux2_x1 1 0 1007 1016 131 1006 mux2_x1
xsubckt_737_mux2_x1 1 0 431 826 911 1039 mux2_x1
xsubckt_292_mux2_x1 1 0 643 655 131 642 mux2_x1
xsubckt_253_mux2_x1 1 0 677 852 135 676 mux2_x1
xsubckt_214_mux2_x1 1 0 710 734 132 709 mux2_x1
xsubckt_451_mux2_x1 1 0 507 555 133 506 mux2_x1
xsubckt_490_mux2_x1 1 0 189 245 136 473 mux2_x1
xsubckt_539_mux2_x1 1 0 182 237 136 431 mux2_x1
xsubckt_578_mux2_x1 1 0 398 422 132 397 mux2_x1
xsubckt_288_mux2_x1 1 0 647 835 135 646 mux2_x1
xsubckt_72_mux2_x1 1 0 250 195 136 839 mux2_x1
xsubckt_33_mux2_x1 1 0 879 880 911 878 mux2_x1
xsubckt_412_mux2_x1 1 0 540 546 130 66 mux2_x1
xsubckt_610_mux2_x1 1 0 371 376 130 35 mux2_x1
xsubckt_882_mux2_x1 1 0 924 936 132 923 mux2_x1
xsubckt_843_mux2_x1 1 0 1019 837 910 953 mux2_x1
xsubckt_684_mux2_x1 1 0 310 390 134 309 mux2_x1
xsubckt_645_mux2_x1 1 0 342 352 131 341 mux2_x1
xsubckt_249_mux2_x1 1 0 680 704 132 679 mux2_x1
xsubckt_161_mux2_x1 1 0 192 171 136 755 mux2_x1
xsubckt_122_mux2_x1 1 0 248 193 136 789 mux2_x1
xsubckt_408_mux2_x1 1 0 544 640 134 543 mux2_x1
xsubckt_447_mux2_x1 1 0 510 516 130 61 mux2_x1
xsubckt_486_mux2_x1 1 0 477 525 133 476 mux2_x1
xsubckt_606_mux2_x1 1 0 375 466 134 374 mux2_x1
xsubckt_804_mux2_x1 1 0 985 1018 133 984 mux2_x1
xsubckt_320_mux2_x1 1 0 619 631 131 618 mux2_x1
xsubckt_196_mux2_x1 1 0 263 165 136 725 mux2_x1
xsubckt_68_mux2_x1 1 0 844 875 907 843 mux2_x1
xsubckt_29_mux2_x1 1 0 154 224 136 882 mux2_x1
xsubckt_157_mux2_x1 1 0 759 884 133 758 mux2_x1
xsubckt_394_mux2_x1 1 0 556 652 134 555 mux2_x1
xsubckt_878_mux2_x1 1 0 927 939 132 926 mux2_x1
xsubckt_839_mux2_x1 1 0 957 989 133 956 mux2_x1
xsubckt_790_mux2_x1 1 0 996 1012 132 995 mux2_x1
xsubckt_751_mux2_x1 1 0 1028 294 133 1027 mux2_x1
xsubckt_316_mux2_x1 1 0 623 827 135 622 mux2_x1
xsubckt_118_mux2_x1 1 0 257 201 136 793 mux2_x1
xsubckt_355_mux2_x1 1 0 589 601 131 588 mux2_x1
xsubckt_514_mux2_x1 1 0 453 501 133 452 mux2_x1
xsubckt_553_mux2_x1 1 0 179 235 136 419 mux2_x1
xsubckt_592_mux2_x1 1 0 386 391 130 38 mux2_x1
xsubckt_786_mux2_x1 1 0 999 1007 131 998 mux2_x1
xsubckt_712_mux2_x1 1 0 286 291 130 16 mux2_x1
xsubckt_588_mux2_x1 1 0 390 484 134 389 mux2_x1
xsubckt_747_mux2_x1 1 0 1031 267 131 1030 mux2_x1
xsubckt_708_mux2_x1 1 0 290 370 134 289 mux2_x1
xsubckt_263_mux2_x1 1 0 668 692 132 667 mux2_x1
xsubckt_224_mux2_x1 1 0 231 161 136 701 mux2_x1
xsubckt_422_mux2_x1 1 0 532 628 134 531 mux2_x1
xsubckt_461_mux2_x1 1 0 498 504 130 59 mux2_x1
xsubckt_549_mux2_x1 1 0 423 471 133 422 mux2_x1
xsubckt_620_mux2_x1 1 0 363 383 132 362 mux2_x1
xsubckt_694_mux2_x1 1 0 301 306 130 19 mux2_x1
xsubckt_298_mux2_x1 1 0 638 662 132 637 mux2_x1
xsubckt_259_mux2_x1 1 0 226 155 136 671 mux2_x1
xsubckt_171_mux2_x1 1 0 747 868 133 746 mux2_x1
xsubckt_43_mux2_x1 1 0 869 872 910 868 mux2_x1
xsubckt_82_mux2_x1 1 0 830 833 910 829 mux2_x1
xsubckt_457_mux2_x1 1 0 502 598 134 501 mux2_x1
xsubckt_496_mux2_x1 1 0 468 474 130 53 mux2_x1
xsubckt_892_mux2_x1 1 0 917 921 131 916 mux2_x1
xsubckt_853_mux2_x1 1 0 977 783 909 945 mux2_x1
xsubckt_814_mux2_x1 1 0 977 1009 133 976 mux2_x1
xsubckt_655_mux2_x1 1 0 334 374 133 333 mux2_x1
xsubckt_78_mux2_x1 1 0 834 835 911 833 mux2_x1
xsubckt_39_mux2_x1 1 0 873 874 911 872 mux2_x1
xsubckt_132_mux2_x1 1 0 780 843 906 129 mux2_x1
xsubckt_330_mux2_x1 1 0 611 811 135 610 mux2_x1
xsubckt_418_mux2_x1 1 0 535 547 131 534 mux2_x1
xsubckt_616_mux2_x1 1 0 366 371 130 33 mux2_x1
xsubckt_888_mux2_x1 1 0 930 845 908 919 mux2_x1
xsubckt_849_mux2_x1 1 0 949 981 133 948 mux2_x1
xsubckt_167_mux2_x1 1 0 750 756 130 56 mux2_x1
xsubckt_128_mux2_x1 1 0 784 787 910 783 mux2_x1
xsubckt_365_mux2_x1 1 0 581 773 135 580 mux2_x1
xsubckt_761_mux2_x1 1 0 407 841 911 1019 mux2_x1
xsubckt_722_mux2_x1 1 0 278 298 132 277 mux2_x1
xsubckt_326_mux2_x1 1 0 614 638 132 613 mux2_x1
xsubckt_524_mux2_x1 1 0 444 450 130 49 mux2_x1
xsubckt_563_mux2_x1 1 0 411 459 133 410 mux2_x1
xsubckt_796_mux2_x1 1 0 991 999 131 990 mux2_x1
xsubckt_757_mux2_x1 1 0 1023 289 133 1022 mux2_x1
xsubckt_273_mux2_x1 1 0 223 153 136 659 mux2_x1
xsubckt_234_mux2_x1 1 0 693 741 133 692 mux2_x1
xsubckt_471_mux2_x1 1 0 490 586 134 489 mux2_x1
xsubckt_559_mux2_x1 1 0 414 420 130 43 mux2_x1
xsubckt_598_mux2_x1 1 0 381 386 130 37 mux2_x1
xdiode_9 1 0 133 diode_w1
xdiode_8 1 0 133 diode_w1
xdiode_7 1 0 133 diode_w1
xdiode_6 1 0 133 diode_w1
xdiode_5 1 0 134 diode_w1
xdiode_4 1 0 134 diode_w1
xdiode_3 1 0 135 diode_w1
xdiode_2 1 0 135 diode_w1
xdiode_1 1 0 136 diode_w1
xdiode_0 1 0 136 diode_w1
xsubckt_718_mux2_x1 1 0 281 286 130 15 mux2_x1
xsubckt_53_mux2_x1 1 0 147 218 136 858 mux2_x1
xsubckt_92_mux2_x1 1 0 155 226 136 819 mux2_x1
xsubckt_432_mux2_x1 1 0 523 535 131 522 mux2_x1
xsubckt_630_mux2_x1 1 0 355 442 134 354 mux2_x1
xsubckt_863_mux2_x1 1 0 938 944 131 937 mux2_x1
xsubckt_665_mux2_x1 1 0 503 838 911 325 mux2_x1
xsubckt_269_mux2_x1 1 0 663 711 133 662 mux2_x1
xsubckt_181_mux2_x1 1 0 738 744 130 34 mux2_x1
xsubckt_14_mux2_x1 1 0 150 220 136 897 mux2_x1
xsubckt_142_mux2_x1 1 0 772 850 134 771 mux2_x1
xsubckt_428_mux2_x1 1 0 527 719 135 526 mux2_x1
xsubckt_467_mux2_x1 1 0 493 505 131 492 mux2_x1
xsubckt_824_mux2_x1 1 0 969 1001 133 968 mux2_x1
xsubckt_301_mux2_x1 1 0 219 149 136 635 mux2_x1
xsubckt_49_mux2_x1 1 0 863 864 911 862 mux2_x1
xsubckt_88_mux2_x1 1 0 164 252 136 823 mux2_x1
xsubckt_103_mux2_x1 1 0 253 197 136 808 mux2_x1
xsubckt_340_mux2_x1 1 0 602 626 132 601 mux2_x1
xsubckt_626_mux2_x1 1 0 358 378 132 357 mux2_x1
xsubckt_898_mux2_x1 1 0 913 914 130 99 mux2_x1
xsubckt_859_mux2_x1 1 0 941 947 131 940 mux2_x1
xsubckt_771_mux2_x1 1 0 1011 1021 131 1010 mux2_x1
xsubckt_177_mux2_x1 1 0 742 833 134 741 mux2_x1
xsubckt_138_mux2_x1 1 0 775 812 131 774 mux2_x1
xsubckt_336_mux2_x1 1 0 213 143 136 605 mux2_x1
xsubckt_375_mux2_x1 1 0 572 596 132 571 mux2_x1
xsubckt_534_mux2_x1 1 0 436 532 134 435 mux2_x1
xsubckt_573_mux2_x1 1 0 402 408 130 41 mux2_x1
xfeed_19 1 0 decap_w0
xfeed_18 1 0 tie
xfeed_17 1 0 tie
xfeed_16 1 0 tie
xfeed_15 1 0 decap_w0
xfeed_13 1 0 decap_w0
xfeed_11 1 0 tie
xfeed_10 1 0 decap_w0
xsubckt_732_mux2_x1 1 0 270 350 134 269 mux2_x1
xsubckt_767_mux2_x1 1 0 401 904 911 1014 mux2_x1
xsubckt_728_mux2_x1 1 0 273 293 132 272 mux2_x1
xsubckt_283_mux2_x1 1 0 651 699 133 650 mux2_x1
xsubckt_244_mux2_x1 1 0 684 690 130 93 mux2_x1
xsubckt_205_mux2_x1 1 0 718 825 134 717 mux2_x1
xsubckt_442_mux2_x1 1 0 515 707 135 514 mux2_x1
xsubckt_481_mux2_x1 1 0 481 493 131 480 mux2_x1
xsubckt_569_mux2_x1 1 0 406 502 134 405 mux2_x1
xfeed_29 1 0 decap_w0
xfeed_28 1 0 tie
xfeed_27 1 0 decap_w0
xfeed_25 1 0 decap_w0
xfeed_22 1 0 decap_w0
xfeed_21 1 0 decap_w0
xfeed_20 1 0 tie
xsubckt_279_mux2_x1 1 0 654 660 130 87 mux2_x1
xsubckt_63_mux2_x1 1 0 174 225 136 848 mux2_x1
xsubckt_24_mux2_x1 1 0 254 198 136 887 mux2_x1
xsubckt_403_mux2_x1 1 0 548 572 132 547 mux2_x1
xsubckt_601_mux2_x1 1 0 379 423 133 378 mux2_x1
xsubckt_640_mux2_x1 1 0 346 351 130 29 mux2_x1
xsubckt_873_mux2_x1 1 0 957 861 909 930 mux2_x1
xsubckt_834_mux2_x1 1 0 961 993 133 960 mux2_x1
xsubckt_675_mux2_x1 1 0 317 327 131 316 mux2_x1
xsubckt_311_mux2_x1 1 0 627 675 133 626 mux2_x1
xsubckt_191_mux2_x1 1 0 730 794 134 729 mux2_x1
xsubckt_6_mux2_x1 1 0 265 176 136 905 mux2_x1
xsubckt_98_mux2_x1 1 0 814 821 909 813 mux2_x1
xsubckt_113_mux2_x1 1 0 799 802 910 798 mux2_x1
xsubckt_152_mux2_x1 1 0 763 775 131 762 mux2_x1
xsubckt_350_mux2_x1 1 0 211 141 136 593 mux2_x1
xsubckt_438_mux2_x1 1 0 518 542 132 517 mux2_x1
xsubckt_477_mux2_x1 1 0 485 677 135 484 mux2_x1
xsubckt_636_mux2_x1 1 0 350 436 134 349 mux2_x1
xfeed_38 1 0 decap_w0
xfeed_37 1 0 decap_w0
xfeed_36 1 0 decap_w0
xfeed_34 1 0 tie
xfeed_30 1 0 tie
xsubckt_187_mux2_x1 1 0 733 745 131 732 mux2_x1
xsubckt_59_mux2_x1 1 0 247 191 136 852 mux2_x1
xsubckt_148_mux2_x1 1 0 767 817 135 766 mux2_x1
xsubckt_385_mux2_x1 1 0 206 261 136 563 mux2_x1
xsubckt_869_mux2_x1 1 0 961 798 909 933 mux2_x1
xsubckt_781_mux2_x1 1 0 1003 1011 131 1002 mux2_x1
xsubckt_742_mux2_x1 1 0 1035 266 130 10 mux2_x1
xsubckt_307_mux2_x1 1 0 630 636 130 83 mux2_x1
xsubckt_109_mux2_x1 1 0 803 804 911 802 mux2_x1
xsubckt_346_mux2_x1 1 0 597 645 133 596 mux2_x1
xsubckt_505_mux2_x1 1 0 461 653 135 460 mux2_x1
xsubckt_544_mux2_x1 1 0 427 439 131 426 mux2_x1
xsubckt_583_mux2_x1 1 0 394 441 133 393 mux2_x1
xfeed_46 1 0 decap_w0
xfeed_45 1 0 tie
xfeed_44 1 0 decap_w0
xfeed_43 1 0 decap_w0
xfeed_42 1 0 decap_w0
xfeed_41 1 0 decap_w0
xsubckt_901_mux2_x1 1 0 912 780 906 97 mux2_x1
xsubckt_777_mux2_x1 1 0 1006 1010 130 4 mux2_x1
xsubckt_703_mux2_x1 1 0 294 334 133 293 mux2_x1
xsubckt_293_mux2_x1 1 0 642 648 130 85 mux2_x1
xsubckt_579_mux2_x1 1 0 397 409 131 396 mux2_x1
xdiode_18 1 0 911 diode_w1
xdiode_17 1 0 130 diode_w1
xdiode_16 1 0 130 diode_w1
xdiode_15 1 0 131 diode_w1
xdiode_14 1 0 131 diode_w1
xdiode_13 1 0 131 diode_w1
xdiode_12 1 0 131 diode_w1
xdiode_11 1 0 132 diode_w1
xdiode_10 1 0 132 diode_w1
xfeed_49 1 0 decap_w0
xfeed_48 1 0 tie
xfeed_47 1 0 tie
xsubckt_738_mux2_x1 1 0 1039 345 134 1038 mux2_x1
xsubckt_650_mux2_x1 1 0 338 358 132 337 mux2_x1
xsubckt_254_mux2_x1 1 0 676 772 134 675 mux2_x1
xsubckt_215_mux2_x1 1 0 709 721 131 708 mux2_x1
xsubckt_413_mux2_x1 1 0 201 257 136 539 mux2_x1
xsubckt_452_mux2_x1 1 0 506 530 132 505 mux2_x1
xsubckt_491_mux2_x1 1 0 473 665 135 472 mux2_x1
xsubckt_611_mux2_x1 1 0 557 863 911 370 mux2_x1
xfeed_53 1 0 decap_w0
xfeed_52 1 0 tie
xfeed_51 1 0 decap_w0
xsubckt_685_mux2_x1 1 0 309 349 133 308 mux2_x1
xsubckt_289_mux2_x1 1 0 646 742 134 645 mux2_x1
xsubckt_162_mux2_x1 1 0 755 801 135 754 mux2_x1
xsubckt_73_mux2_x1 1 0 160 230 136 838 mux2_x1
xsubckt_34_mux2_x1 1 0 878 881 910 877 mux2_x1
xsubckt_448_mux2_x1 1 0 196 251 136 509 mux2_x1
xsubckt_487_mux2_x1 1 0 476 500 132 475 mux2_x1
xfeed_108 1 0 decap_w0
xfeed_107 1 0 decap_w0
xfeed_106 1 0 decap_w0
xfeed_105 1 0 decap_w0
xfeed_104 1 0 decap_w0
xfeed_103 1 0 decap_w0
xfeed_102 1 0 decap_w0
xfeed_101 1 0 decap_w0
xfeed_100 1 0 tie
xfeed_59 1 0 decap_w0
xfeed_58 1 0 tie
xfeed_57 1 0 tie
xfeed_56 1 0 decap_w0
xfeed_55 1 0 decap_w0
xfeed_54 1 0 decap_w0
xsubckt_883_mux2_x1 1 0 923 929 131 922 mux2_x1
xsubckt_844_mux2_x1 1 0 953 985 133 952 mux2_x1
xsubckt_805_mux2_x1 1 0 984 1000 132 983 mux2_x1
xsubckt_646_mux2_x1 1 0 341 346 130 28 mux2_x1
xsubckt_69_mux2_x1 1 0 233 177 136 842 mux2_x1
xsubckt_123_mux2_x1 1 0 157 228 136 788 mux2_x1
xsubckt_321_mux2_x1 1 0 618 624 130 81 mux2_x1
xsubckt_360_mux2_x1 1 0 585 633 133 584 mux2_x1
xsubckt_409_mux2_x1 1 0 543 591 133 542 mux2_x1
xsubckt_607_mux2_x1 1 0 374 417 133 373 mux2_x1
xfeed_60 1 0 tie
xsubckt_879_mux2_x1 1 0 926 932 131 925 mux2_x1
xsubckt_791_mux2_x1 1 0 995 1003 131 994 mux2_x1
xsubckt_197_mux2_x1 1 0 725 856 135 724 mux2_x1
xsubckt_119_mux2_x1 1 0 166 148 136 792 mux2_x1
xsubckt_158_mux2_x1 1 0 758 891 132 757 mux2_x1
xsubckt_356_mux2_x1 1 0 588 594 130 75 mux2_x1
xsubckt_395_mux2_x1 1 0 555 603 133 554 mux2_x1
xsubckt_593_mux2_x1 1 0 575 816 911 385 mux2_x1
xfeed_119 1 0 decap_w0
xfeed_118 1 0 tie
xfeed_117 1 0 decap_w0
xfeed_116 1 0 decap_w0
xfeed_115 1 0 decap_w0
xfeed_114 1 0 decap_w0
xfeed_113 1 0 decap_w0
xfeed_112 1 0 decap_w0
xfeed_111 1 0 decap_w0
xfeed_110 1 0 decap_w0
xfeed_69 1 0 decap_w0
xfeed_68 1 0 decap_w0
xfeed_67 1 0 decap_w0
xfeed_66 1 0 decap_w0
xfeed_65 1 0 decap_w0
xfeed_64 1 0 tie
xfeed_63 1 0 tie
xfeed_62 1 0 tie
xsubckt_752_mux2_x1 1 0 1027 273 132 1026 mux2_x1
xsubckt_713_mux2_x1 1 0 455 834 911 285 mux2_x1
xsubckt_317_mux2_x1 1 0 622 718 134 621 mux2_x1
xsubckt_515_mux2_x1 1 0 452 476 132 451 mux2_x1
xsubckt_554_mux2_x1 1 0 419 611 135 418 mux2_x1
xsubckt_787_mux2_x1 1 0 998 1002 130 2 mux2_x1
xsubckt_748_mux2_x1 1 0 1030 1035 130 9 mux2_x1
xsubckt_264_mux2_x1 1 0 667 679 131 666 mux2_x1
xsubckt_225_mux2_x1 1 0 701 871 135 700 mux2_x1
xsubckt_462_mux2_x1 1 0 194 249 136 497 mux2_x1
xsubckt_589_mux2_x1 1 0 389 435 133 388 mux2_x1
xfeed_129 1 0 decap_w0
xfeed_128 1 0 decap_w0
xfeed_127 1 0 decap_w0
xfeed_126 1 0 decap_w0
xfeed_125 1 0 tie
xfeed_124 1 0 decap_w0
xfeed_123 1 0 tie
xfeed_122 1 0 decap_w0
xfeed_121 1 0 tie
xfeed_120 1 0 decap_w0
xfeed_79 1 0 decap_w0
xfeed_78 1 0 decap_w0
xfeed_77 1 0 decap_w0
xfeed_76 1 0 tie
xfeed_75 1 0 decap_w0
xfeed_74 1 0 decap_w0
xfeed_73 1 0 decap_w0
xfeed_72 1 0 decap_w0
xfeed_71 1 0 tie
xfeed_70 1 0 decap_w0
xsubckt_709_mux2_x1 1 0 289 329 133 288 mux2_x1
xsubckt_660_mux2_x1 1 0 330 412 134 329 mux2_x1
xsubckt_299_mux2_x1 1 0 637 649 131 636 mux2_x1
xsubckt_44_mux2_x1 1 0 243 187 136 867 mux2_x1
xsubckt_83_mux2_x1 1 0 829 836 909 828 mux2_x1
xsubckt_423_mux2_x1 1 0 531 579 133 530 mux2_x1
xsubckt_621_mux2_x1 1 0 362 372 131 361 mux2_x1
xsubckt_893_mux2_x1 1 0 916 918 130 101 mux2_x1
xsubckt_854_mux2_x1 1 0 945 960 132 944 mux2_x1
xsubckt_695_mux2_x1 1 0 473 882 911 300 mux2_x1
xsubckt_656_mux2_x1 1 0 333 353 132 332 mux2_x1
xsubckt_172_mux2_x1 1 0 746 770 132 745 mux2_x1
xsubckt_133_mux2_x1 1 0 264 175 136 779 mux2_x1
xsubckt_370_mux2_x1 1 0 576 582 130 73 mux2_x1
xsubckt_419_mux2_x1 1 0 534 540 130 65 mux2_x1
xsubckt_458_mux2_x1 1 0 501 549 133 500 mux2_x1
xsubckt_497_mux2_x1 1 0 188 244 136 467 mux2_x1
xfeed_139 1 0 decap_w0
xfeed_138 1 0 decap_w0
xfeed_137 1 0 decap_w0
xfeed_136 1 0 tie
xfeed_135 1 0 decap_w0
xfeed_134 1 0 decap_w0
xfeed_133 1 0 decap_w0
xfeed_132 1 0 decap_w0
xfeed_131 1 0 tie
xfeed_130 1 0 tie
xfeed_89 1 0 decap_w0
xfeed_88 1 0 decap_w0
xfeed_87 1 0 tie
xfeed_86 1 0 tie
xfeed_85 1 0 tie
xfeed_84 1 0 decap_w0
xfeed_83 1 0 decap_w0
xfeed_82 1 0 decap_w0
xfeed_81 1 0 decap_w0
xfeed_80 1 0 decap_w0
xsubckt_815_mux2_x1 1 0 976 992 132 975 mux2_x1
xsubckt_79_mux2_x1 1 0 259 204 136 832 mux2_x1
xsubckt_331_mux2_x1 1 0 610 706 134 609 mux2_x1
xsubckt_617_mux2_x1 1 0 551 831 911 365 mux2_x1
xsubckt_889_mux2_x1 1 0 919 923 131 918 mux2_x1
xsubckt_762_mux2_x1 1 0 1019 325 134 1018 mux2_x1
xsubckt_168_mux2_x1 1 0 181 169 136 749 mux2_x1
xsubckt_129_mux2_x1 1 0 783 790 909 782 mux2_x1
xsubckt_327_mux2_x1 1 0 613 625 131 612 mux2_x1
xsubckt_366_mux2_x1 1 0 580 676 134 579 mux2_x1
xsubckt_525_mux2_x1 1 0 184 239 136 443 mux2_x1
xsubckt_564_mux2_x1 1 0 410 434 132 409 mux2_x1
xfeed_149 1 0 decap_w0
xfeed_147 1 0 tie
xfeed_146 1 0 decap_w0
xfeed_145 1 0 decap_w0
xfeed_144 1 0 tie
xfeed_143 1 0 tie
xfeed_142 1 0 decap_w0
xfeed_141 1 0 decap_w0
xfeed_140 1 0 tie
xfeed_99 1 0 tie
xfeed_98 1 0 decap_w0
xfeed_97 1 0 decap_w0
xfeed_96 1 0 decap_w0
xfeed_95 1 0 decap_w0
xfeed_94 1 0 decap_w0
xfeed_93 1 0 decap_w0
xfeed_92 1 0 tie
xfeed_91 1 0 decap_w0
xfeed_90 1 0 decap_w0
xsubckt_723_mux2_x1 1 0 277 287 131 276 mux2_x1
xsubckt_200_mux2_x1 1 0 722 746 132 721 mux2_x1
xsubckt_599_mux2_x1 1 0 569 879 911 380 mux2_x1
xsubckt_797_mux2_x1 1 0 990 994 130 125 mux2_x1
xsubckt_758_mux2_x1 1 0 1022 268 132 1021 mux2_x1
xsubckt_719_mux2_x1 1 0 449 897 911 280 mux2_x1
xsubckt_670_mux2_x1 1 0 321 326 130 24 mux2_x1
xsubckt_274_mux2_x1 1 0 659 804 135 658 mux2_x1
xsubckt_235_mux2_x1 1 0 692 716 132 691 mux2_x1
xsubckt_433_mux2_x1 1 0 522 528 130 63 mux2_x1
xsubckt_472_mux2_x1 1 0 489 537 133 488 mux2_x1
xfeed_159 1 0 decap_w0
xfeed_158 1 0 decap_w0
xfeed_157 1 0 decap_w0
xfeed_156 1 0 decap_w0
xfeed_155 1 0 decap_w0
xfeed_154 1 0 tie
xfeed_153 1 0 decap_w0
xfeed_152 1 0 decap_w0
xfeed_151 1 0 decap_w0
xfeed_150 1 0 decap_w0
xsubckt_54_mux2_x1 1 0 858 859 911 857 mux2_x1
xsubckt_15_mux2_x1 1 0 897 898 911 896 mux2_x1
xsubckt_93_mux2_x1 1 0 819 820 911 818 mux2_x1
xsubckt_468_mux2_x1 1 0 492 498 130 58 mux2_x1
xsubckt_631_mux2_x1 1 0 354 394 133 353 mux2_x1
xsubckt_864_mux2_x1 1 0 937 940 130 110 mux2_x1
xsubckt_825_mux2_x1 1 0 968 984 132 967 mux2_x1
xsubckt_666_mux2_x1 1 0 325 406 134 324 mux2_x1
xsubckt_302_mux2_x1 1 0 635 796 135 634 mux2_x1
xsubckt_182_mux2_x1 1 0 159 167 136 737 mux2_x1
xsubckt_89_mux2_x1 1 0 823 824 911 822 mux2_x1
xsubckt_104_mux2_x1 1 0 162 232 136 807 mux2_x1
xsubckt_143_mux2_x1 1 0 771 853 133 770 mux2_x1
xsubckt_341_mux2_x1 1 0 601 613 131 600 mux2_x1
xsubckt_380_mux2_x1 1 0 568 664 134 567 mux2_x1
xsubckt_429_mux2_x1 1 0 526 622 134 525 mux2_x1
xsubckt_627_mux2_x1 1 0 357 367 131 356 mux2_x1
xfeed_209 1 0 decap_w0
xfeed_208 1 0 decap_w0
xfeed_207 1 0 decap_w0
xfeed_206 1 0 decap_w0
xfeed_205 1 0 decap_w0
xfeed_204 1 0 decap_w0
xfeed_203 1 0 decap_w0
xfeed_202 1 0 decap_w0
xfeed_201 1 0 decap_w0
xfeed_200 1 0 decap_w0
xfeed_169 1 0 decap_w0
xfeed_168 1 0 decap_w0
xfeed_167 1 0 decap_w0
xfeed_166 1 0 decap_w0
xfeed_165 1 0 decap_w0
xfeed_164 1 0 decap_w0
xfeed_163 1 0 decap_w0
xfeed_162 1 0 decap_w0
xfeed_161 1 0 decap_w0
xfeed_160 1 0 decap_w0
xsubckt_899_mux2_x1 1 0 915 844 907 912 mux2_x1
xsubckt_178_mux2_x1 1 0 741 836 133 740 mux2_x1
xsubckt_139_mux2_x1 1 0 774 843 130 128 mux2_x1
xsubckt_376_mux2_x1 1 0 571 583 131 570 mux2_x1
xsubckt_500_mux2_x1 1 0 465 513 133 464 mux2_x1
xsubckt_772_mux2_x1 1 0 1010 1015 130 5 mux2_x1
xsubckt_733_mux2_x1 1 0 269 309 133 268 mux2_x1
xsubckt_210_mux2_x1 1 0 241 163 136 713 mux2_x1
xsubckt_337_mux2_x1 1 0 605 874 135 604 mux2_x1
xsubckt_535_mux2_x1 1 0 435 483 133 434 mux2_x1
xsubckt_574_mux2_x1 1 0 176 265 136 401 mux2_x1
xfeed_219 1 0 decap_w0
xfeed_218 1 0 decap_w0
xfeed_217 1 0 decap_w0
xfeed_216 1 0 decap_w0
xfeed_215 1 0 decap_w0
xfeed_214 1 0 decap_w0
xfeed_213 1 0 decap_w0
xfeed_212 1 0 decap_w0
xfeed_211 1 0 decap_w0
xfeed_210 1 0 decap_w0
xfeed_179 1 0 decap_w0
xfeed_178 1 0 decap_w0
xfeed_177 1 0 decap_w0
xfeed_176 1 0 tie
xfeed_175 1 0 tie
xfeed_174 1 0 decap_w0
xfeed_173 1 0 decap_w0
xfeed_172 1 0 decap_w0
xfeed_171 1 0 tie
xfeed_170 1 0 decap_w0
xsubckt_768_mux2_x1 1 0 1014 320 134 1013 mux2_x1
xsubckt_284_mux2_x1 1 0 650 674 132 649 mux2_x1
xsubckt_482_mux2_x1 1 0 480 486 130 55 mux2_x1
xsubckt_729_mux2_x1 1 0 272 282 131 271 mux2_x1
xsubckt_680_mux2_x1 1 0 313 333 132 312 mux2_x1
xsubckt_641_mux2_x1 1 0 527 823 911 345 mux2_x1
xsubckt_245_mux2_x1 1 0 228 157 136 683 mux2_x1
xsubckt_206_mux2_x1 1 0 717 765 133 716 mux2_x1
xsubckt_404_mux2_x1 1 0 547 559 131 546 mux2_x1
xsubckt_443_mux2_x1 1 0 514 610 134 513 mux2_x1
xsubckt_602_mux2_x1 1 0 378 398 132 377 mux2_x1
xfeed_229 1 0 decap_w0
xfeed_228 1 0 decap_w0
xfeed_227 1 0 decap_w0
xfeed_226 1 0 decap_w0
xfeed_225 1 0 decap_w0
xfeed_224 1 0 decap_w0
xfeed_223 1 0 tie
xfeed_222 1 0 decap_w0
xfeed_221 1 0 tie
xfeed_220 1 0 decap_w0
xfeed_189 1 0 decap_w0
xfeed_188 1 0 decap_w0
xfeed_187 1 0 decap_w0
xfeed_186 1 0 decap_w0
xfeed_185 1 0 decap_w0
xfeed_184 1 0 decap_w0
xfeed_183 1 0 decap_w0
xfeed_182 1 0 decap_w0
xfeed_181 1 0 decap_w0
xfeed_180 1 0 decap_w0
xsubckt_800_mux2_x1 1 0 988 1004 132 987 mux2_x1
xsubckt_676_mux2_x1 1 0 316 321 130 22 mux2_x1
xsubckt_192_mux2_x1 1 0 729 777 133 728 mux2_x1
xsubckt_64_mux2_x1 1 0 848 849 911 847 mux2_x1
xsubckt_25_mux2_x1 1 0 163 241 136 886 mux2_x1
xsubckt_153_mux2_x1 1 0 762 768 130 78 mux2_x1
xsubckt_390_mux2_x1 1 0 559 571 131 558 mux2_x1
xsubckt_439_mux2_x1 1 0 517 529 131 516 mux2_x1
xsubckt_478_mux2_x1 1 0 484 580 134 483 mux2_x1
xsubckt_874_mux2_x1 1 0 930 942 132 929 mux2_x1
xsubckt_835_mux2_x1 1 0 960 976 132 959 mux2_x1
xsubckt_312_mux2_x1 1 0 626 650 132 625 mux2_x1
xsubckt_7_mux2_x1 1 0 141 211 136 904 mux2_x1
xsubckt_99_mux2_x1 1 0 813 828 908 812 mux2_x1
xsubckt_114_mux2_x1 1 0 798 805 909 797 mux2_x1
xsubckt_351_mux2_x1 1 0 593 905 135 592 mux2_x1
xsubckt_510_mux2_x1 1 0 456 462 130 51 mux2_x1
xsubckt_637_mux2_x1 1 0 349 389 133 348 mux2_x1
xfeed_239 1 0 decap_w0
xfeed_238 1 0 decap_w0
xfeed_237 1 0 decap_w0
xfeed_236 1 0 decap_w0
xfeed_235 1 0 decap_w0
xfeed_234 1 0 decap_w0
xfeed_233 1 0 decap_w0
xfeed_232 1 0 decap_w0
xfeed_231 1 0 decap_w0
xfeed_230 1 0 decap_w0
xfeed_199 1 0 decap_w0
xfeed_198 1 0 decap_w0
xfeed_197 1 0 tie
xfeed_196 1 0 tie
xfeed_195 1 0 decap_w0
xfeed_194 1 0 decap_w0
xfeed_193 1 0 decap_w0
xfeed_192 1 0 tie
xfeed_191 1 0 decap_w0
xfeed_190 1 0 decap_w0
xsubckt_782_mux2_x1 1 0 1002 1006 130 3 mux2_x1
xsubckt_188_mux2_x1 1 0 732 738 130 23 mux2_x1
xsubckt_149_mux2_x1 1 0 766 818 134 765 mux2_x1
xsubckt_347_mux2_x1 1 0 596 620 132 595 mux2_x1
xsubckt_386_mux2_x1 1 0 563 755 135 562 mux2_x1
xsubckt_545_mux2_x1 1 0 426 432 130 46 mux2_x1
xsubckt_584_mux2_x1 1 0 393 416 132 392 mux2_x1
xsubckt_743_mux2_x1 1 0 425 889 911 1034 mux2_x1
xsubckt_704_mux2_x1 1 0 293 313 132 292 mux2_x1
xsubckt_308_mux2_x1 1 0 218 147 136 629 mux2_x1
xsubckt_220_mux2_x1 1 0 705 753 133 704 mux2_x1
xsubckt_506_mux2_x1 1 0 460 556 134 459 mux2_x1
xfeed_249 1 0 tie
xfeed_247 1 0 tie
xfeed_246 1 0 tie
xfeed_245 1 0 decap_w0
xfeed_244 1 0 decap_w0
xfeed_243 1 0 decap_w0
xfeed_242 1 0 decap_w0
xfeed_241 1 0 decap_w0
xfeed_240 1 0 decap_w0
xsubckt_778_mux2_x1 1 0 310 847 910 1005 mux2_x1
xsubckt_739_mux2_x1 1 0 1038 304 133 1037 mux2_x1
xsubckt_690_mux2_x1 1 0 305 385 134 304 mux2_x1
xsubckt_294_mux2_x1 1 0 220 150 136 641 mux2_x1
xsubckt_255_mux2_x1 1 0 675 723 133 674 mux2_x1
xsubckt_216_mux2_x1 1 0 708 714 130 105 mux2_x1
xsubckt_453_mux2_x1 1 0 505 517 131 504 mux2_x1
xsubckt_492_mux2_x1 1 0 472 568 134 471 mux2_x1
xfeed_9 1 0 tie
xfeed_8 1 0 decap_w0
xfeed_7 1 0 tie
xfeed_6 1 0 decap_w0
xfeed_5 1 0 decap_w0
xfeed_4 1 0 decap_w0
xfeed_3 1 0 tie
xfeed_1 1 0 tie
xsubckt_810_mux2_x1 1 0 980 996 132 979 mux2_x1
xsubckt_651_mux2_x1 1 0 337 347 131 336 mux2_x1
xsubckt_74_mux2_x1 1 0 838 839 911 837 mux2_x1
xsubckt_35_mux2_x1 1 0 877 884 909 876 mux2_x1
xsubckt_414_mux2_x1 1 0 539 731 135 538 mux2_x1
xsubckt_612_mux2_x1 1 0 370 460 134 369 mux2_x1
xfeed_258 1 0 tie
xfeed_257 1 0 tie
xfeed_256 1 0 tie
xfeed_255 1 0 tie
xfeed_254 1 0 tie
xfeed_253 1 0 tie
xfeed_252 1 0 tie
xfeed_251 1 0 tie
xfeed_250 1 0 tie
xsubckt_884_mux2_x1 1 0 922 925 130 104 mux2_x1
xsubckt_845_mux2_x1 1 0 952 968 132 951 mux2_x1
xsubckt_686_mux2_x1 1 0 308 328 132 307 mux2_x1
xsubckt_647_mux2_x1 1 0 521 886 911 340 mux2_x1
xsubckt_163_mux2_x1 1 0 754 802 134 753 mux2_x1
xsubckt_124_mux2_x1 1 0 788 789 911 787 mux2_x1
xsubckt_361_mux2_x1 1 0 584 608 132 583 mux2_x1
xsubckt_449_mux2_x1 1 0 509 701 135 508 mux2_x1
xsubckt_488_mux2_x1 1 0 475 487 131 474 mux2_x1
xsubckt_608_mux2_x1 1 0 373 393 132 372 mux2_x1
xsubckt_806_mux2_x1 1 0 983 991 131 982 mux2_x1
xsubckt_198_mux2_x1 1 0 724 857 134 723 mux2_x1
xsubckt_322_mux2_x1 1 0 216 145 136 617 mux2_x1
xsubckt_396_mux2_x1 1 0 554 578 132 553 mux2_x1
xsubckt_520_mux2_x1 1 0 448 544 134 447 mux2_x1
xsubckt_792_mux2_x1 1 0 994 998 130 126 mux2_x1
xsubckt_753_mux2_x1 1 0 1026 1036 131 1025 mux2_x1
xsubckt_318_mux2_x1 1 0 621 669 133 620 mux2_x1
xsubckt_230_mux2_x1 1 0 696 702 130 95 mux2_x1
xsubckt_159_mux2_x1 1 0 757 769 131 756 mux2_x1
xsubckt_357_mux2_x1 1 0 210 140 136 587 mux2_x1
xsubckt_516_mux2_x1 1 0 451 463 131 450 mux2_x1
xsubckt_555_mux2_x1 1 0 418 514 134 417 mux2_x1
xsubckt_594_mux2_x1 1 0 385 478 134 384 mux2_x1
xsubckt_788_mux2_x1 1 0 300 878 910 997 mux2_x1
xsubckt_714_mux2_x1 1 0 285 365 134 284 mux2_x1
xspare_feed_13 1 0 decap_w0
xspare_feed_12 1 0 tie
xspare_feed_11 1 0 tie
xspare_feed_10 1 0 decap_w0
xsubckt_749_mux2_x1 1 0 419 810 911 1029 mux2_x1
xsubckt_661_mux2_x1 1 0 329 369 133 328 mux2_x1
xsubckt_265_mux2_x1 1 0 666 672 130 90 mux2_x1
xsubckt_226_mux2_x1 1 0 700 872 134 699 mux2_x1
xsubckt_10_mux2_x1 1 0 158 229 136 901 mux2_x1
xsubckt_424_mux2_x1 1 0 530 554 132 529 mux2_x1
xsubckt_463_mux2_x1 1 0 497 689 135 496 mux2_x1
xsubckt_622_mux2_x1 1 0 361 366 130 32 mux2_x1
xspare_feed_15 1 0 tie
xspare_feed_14 1 0 tie
xsubckt_820_mux2_x1 1 0 972 988 132 971 mux2_x1
xsubckt_696_mux2_x1 1 0 300 380 134 299 mux2_x1
xsubckt_45_mux2_x1 1 0 152 222 136 866 mux2_x1
xsubckt_84_mux2_x1 1 0 237 182 136 827 mux2_x1
xsubckt_459_mux2_x1 1 0 500 524 132 499 mux2_x1
xsubckt_498_mux2_x1 1 0 467 659 135 466 mux2_x1
xsubckt_894_mux2_x1 1 0 924 876 908 915 mux2_x1
xsubckt_855_mux2_x1 1 0 944 951 131 943 mux2_x1
xsubckt_816_mux2_x1 1 0 975 983 131 974 mux2_x1
xsubckt_657_mux2_x1 1 0 332 342 131 331 mux2_x1
xsubckt_173_mux2_x1 1 0 745 757 131 744 mux2_x1
xsubckt_134_mux2_x1 1 0 779 786 135 778 mux2_x1
xsubckt_332_mux2_x1 1 0 609 657 133 608 mux2_x1
xsubckt_371_mux2_x1 1 0 208 138 136 575 mux2_x1
xsubckt_530_mux2_x1 1 0 439 451 131 438 mux2_x1
xsubckt_618_mux2_x1 1 0 365 454 134 364 mux2_x1
xsubckt_169_mux2_x1 1 0 749 864 135 748 mux2_x1
xsubckt_367_mux2_x1 1 0 579 627 133 578 mux2_x1
xspare_feed_9 1 0 tie
xspare_feed_8 1 0 tie
xspare_feed_7 1 0 decap_w0
xspare_feed_6 1 0 tie
xspare_feed_4 1 0 decap_w0
xspare_feed_3 1 0 tie
xspare_feed_2 1 0 tie
xspare_feed_1 1 0 tie
xspare_feed_0 1 0 tie
xsubckt_763_mux2_x1 1 0 1018 284 133 1017 mux2_x1
xsubckt_724_mux2_x1 1 0 276 281 130 14 mux2_x1
xsubckt_240_mux2_x1 1 0 688 903 134 687 mux2_x1
xsubckt_201_mux2_x1 1 0 721 733 131 720 mux2_x1
xsubckt_328_mux2_x1 1 0 612 618 130 80 mux2_x1
xsubckt_526_mux2_x1 1 0 443 635 135 442 mux2_x1
xsubckt_565_mux2_x1 1 0 409 421 131 408 mux2_x1
xsubckt_798_mux2_x1 1 0 290 862 910 989 mux2_x1
xsubckt_759_mux2_x1 1 0 1021 1031 131 1020 mux2_x1
xsubckt_275_mux2_x1 1 0 658 754 134 657 mux2_x1
xsubckt_20_mux2_x1 1 0 892 899 909 891 mux2_x1
xsubckt_473_mux2_x1 1 0 488 512 132 487 mux2_x1
xsubckt_830_mux2_x1 1 0 964 980 132 963 mux2_x1
xsubckt_671_mux2_x1 1 0 497 901 911 320 mux2_x1
xsubckt_236_mux2_x1 1 0 691 703 131 690 mux2_x1
xsubckt_55_mux2_x1 1 0 256 200 136 856 mux2_x1
xsubckt_94_mux2_x1 1 0 138 208 136 817 mux2_x1
xsubckt_434_mux2_x1 1 0 198 254 136 521 mux2_x1
xsubckt_632_mux2_x1 1 0 353 373 132 352 mux2_x1
xsubckt_865_mux2_x1 1 0 965 877 909 936 mux2_x1
xsubckt_667_mux2_x1 1 0 324 364 133 323 mux2_x1
xsubckt_183_mux2_x1 1 0 737 895 135 736 mux2_x1
xsubckt_16_mux2_x1 1 0 258 202 136 895 mux2_x1
xsubckt_144_mux2_x1 1 0 770 860 132 769 mux2_x1
xsubckt_381_mux2_x1 1 0 567 615 133 566 mux2_x1
xsubckt_469_mux2_x1 1 0 193 248 136 491 mux2_x1
xsubckt_826_mux2_x1 1 0 967 975 131 966 mux2_x1
xsubckt_303_mux2_x1 1 0 634 730 134 633 mux2_x1
xsubckt_105_mux2_x1 1 0 807 808 911 806 mux2_x1
xsubckt_342_mux2_x1 1 0 600 606 130 77 mux2_x1
xsubckt_501_mux2_x1 1 0 464 488 132 463 mux2_x1
xsubckt_540_mux2_x1 1 0 431 623 135 430 mux2_x1
xsubckt_628_mux2_x1 1 0 356 361 130 31 mux2_x1
xsubckt_773_mux2_x1 1 0 315 784 910 1009 mux2_x1
xsubckt_179_mux2_x1 1 0 740 764 132 739 mux2_x1
xsubckt_338_mux2_x1 1 0 604 700 134 603 mux2_x1
xsubckt_377_mux2_x1 1 0 570 576 130 72 mux2_x1
xsubckt_536_mux2_x1 1 0 434 458 132 433 mux2_x1
xsubckt_575_mux2_x1 1 0 401 593 135 400 mux2_x1
.ends rot_r
