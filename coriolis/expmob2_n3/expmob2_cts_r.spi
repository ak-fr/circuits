* Coriolis Structural SPICE Driver
* Generated on Apr 15, 2025, 15:39
* Cell/Subckt "expmob2_cts_r".
*
* INTERF vss
* INTERF vdd
* INTERF outputs[7]
* INTERF outputs[6]
* INTERF outputs[5]
* INTERF outputs[4]
* INTERF outputs[3]
* INTERF outputs[2]
* INTERF outputs[1]
* INTERF outputs[0]
* INTERF inputs[7]
* INTERF inputs[6]
* INTERF inputs[5]
* INTERF inputs[4]
* INTERF inputs[3]
* INTERF inputs[2]
* INTERF inputs[1]
* INTERF inputs[0]
* INTERF clk

* Terminal models (aka standard cells) used througout all the hierarchy.
.include and3_x1.spi
.include and2_x1.spi
.include and4_x1.spi
.include nexor2_x0.spi
.include nand4_x0.spi
.include nand2_x0.spi
.include inv_x0.spi
.include nand3_x0.spi
.include dff_x1.spi
.include xor2_x0.spi
.include nor4_x0.spi
.include decap_w0.spi
.include tie.spi
.include and21nor_x0.spi
.include or21nand_x0.spi
.include nor2_x0.spi
.include one_x1.spi
.include buf_x4.spi
.include mux2_x1.spi

* Non-terminal models (part of the user's design hierarchy).

.subckt expmob2_cts_r 0 1 2 3 4 5 6 7 8 9 47 48 49 50 51 52 53 54 59
* NET     0 = vss
* NET     1 = vdd
* NET     2 = outputs[7]
* NET     3 = outputs[6]
* NET     4 = outputs[5]
* NET     5 = outputs[4]
* NET     6 = outputs[3]
* NET     7 = outputs[2]
* NET     8 = outputs[1]
* NET     9 = outputs[0]
* NET    10 = one_0
* NET    11 = n[9]
* NET    12 = n[8]
* NET    13 = n[7]
* NET    14 = n[6]
* NET    15 = n[5]
* NET    16 = n[4]
* NET    17 = n[31]
* NET    18 = n[30]
* NET    19 = n[3]
* NET    20 = n[29]
* NET    21 = n[28]
* NET    22 = n[27]
* NET    23 = n[26]
* NET    24 = n[25]
* NET    25 = n[24]
* NET    26 = n[23]
* NET    27 = n[22]
* NET    28 = n[21]
* NET    29 = n[20]
* NET    30 = n[2]
* NET    31 = n[19]
* NET    32 = n[18]
* NET    33 = n[17]
* NET    34 = n[16]
* NET    35 = n[15]
* NET    36 = n[14]
* NET    37 = n[13]
* NET    38 = n[12]
* NET    39 = n[11]
* NET    40 = n[10]
* NET    41 = n[1]
* NET    42 = n[0]
* NET    43 = mem_inputs[7]
* NET    44 = mem_inputs[6]
* NET    45 = mem_inputs[5]
* NET    46 = mem_inputs[4]
* NET    47 = inputs[7]
* NET    48 = inputs[6]
* NET    49 = inputs[5]
* NET    50 = inputs[4]
* NET    51 = inputs[3]
* NET    52 = inputs[2]
* NET    53 = inputs[1]
* NET    54 = inputs[0]
* NET    55 = init
* NET    56 = clk_root_2
* NET    57 = clk_root_1
* NET    58 = clk_root_0
* NET    59 = clk
* NET    60 = blockagenet
* NET    61 = abc_1402_new_n99
* NET    62 = abc_1402_new_n98
* NET    63 = abc_1402_new_n97
* NET    64 = abc_1402_new_n96
* NET    65 = abc_1402_new_n95
* NET    66 = abc_1402_new_n94
* NET    67 = abc_1402_new_n255
* NET    68 = abc_1402_new_n254
* NET    69 = abc_1402_new_n253
* NET    70 = abc_1402_new_n251
* NET    71 = abc_1402_new_n250
* NET    72 = abc_1402_new_n249
* NET    73 = abc_1402_new_n247
* NET    74 = abc_1402_new_n246
* NET    75 = abc_1402_new_n245
* NET    76 = abc_1402_new_n243
* NET    77 = abc_1402_new_n242
* NET    78 = abc_1402_new_n241
* NET    79 = abc_1402_new_n239
* NET    80 = abc_1402_new_n238
* NET    81 = abc_1402_new_n237
* NET    82 = abc_1402_new_n235
* NET    83 = abc_1402_new_n234
* NET    84 = abc_1402_new_n233
* NET    85 = abc_1402_new_n231
* NET    86 = abc_1402_new_n230
* NET    87 = abc_1402_new_n229
* NET    88 = abc_1402_new_n225
* NET    89 = abc_1402_new_n223
* NET    90 = abc_1402_new_n221
* NET    91 = abc_1402_new_n219
* NET    92 = abc_1402_new_n217
* NET    93 = abc_1402_new_n216
* NET    94 = abc_1402_new_n214
* NET    95 = abc_1402_new_n212
* NET    96 = abc_1402_new_n210
* NET    97 = abc_1402_new_n208
* NET    98 = abc_1402_new_n207
* NET    99 = abc_1402_new_n206
* NET   100 = abc_1402_new_n205
* NET   101 = abc_1402_new_n204
* NET   102 = abc_1402_new_n203
* NET   103 = abc_1402_new_n202
* NET   104 = abc_1402_new_n201
* NET   105 = abc_1402_new_n199
* NET   106 = abc_1402_new_n198
* NET   107 = abc_1402_new_n197
* NET   108 = abc_1402_new_n196
* NET   109 = abc_1402_new_n195
* NET   110 = abc_1402_new_n194
* NET   111 = abc_1402_new_n191
* NET   112 = abc_1402_new_n189
* NET   113 = abc_1402_new_n188
* NET   114 = abc_1402_new_n186
* NET   115 = abc_1402_new_n184
* NET   116 = abc_1402_new_n182
* NET   117 = abc_1402_new_n181
* NET   118 = abc_1402_new_n180
* NET   119 = abc_1402_new_n179
* NET   120 = abc_1402_new_n178
* NET   121 = abc_1402_new_n175
* NET   122 = abc_1402_new_n173
* NET   123 = abc_1402_new_n171
* NET   124 = abc_1402_new_n170
* NET   125 = abc_1402_new_n168
* NET   126 = abc_1402_new_n167
* NET   127 = abc_1402_new_n165
* NET   128 = abc_1402_new_n163
* NET   129 = abc_1402_new_n161
* NET   130 = abc_1402_new_n160
* NET   131 = abc_1402_new_n158
* NET   132 = abc_1402_new_n156
* NET   133 = abc_1402_new_n154
* NET   134 = abc_1402_new_n153
* NET   135 = abc_1402_new_n151
* NET   136 = abc_1402_new_n149
* NET   137 = abc_1402_new_n147
* NET   138 = abc_1402_new_n146
* NET   139 = abc_1402_new_n145
* NET   140 = abc_1402_new_n144
* NET   141 = abc_1402_new_n143
* NET   142 = abc_1402_new_n142
* NET   143 = abc_1402_new_n141
* NET   144 = abc_1402_new_n140
* NET   145 = abc_1402_new_n139
* NET   146 = abc_1402_new_n138
* NET   147 = abc_1402_new_n137
* NET   148 = abc_1402_new_n136
* NET   149 = abc_1402_new_n135
* NET   150 = abc_1402_new_n134
* NET   151 = abc_1402_new_n133
* NET   152 = abc_1402_new_n132
* NET   153 = abc_1402_new_n131
* NET   154 = abc_1402_new_n130
* NET   155 = abc_1402_new_n129
* NET   156 = abc_1402_new_n124
* NET   157 = abc_1402_new_n123
* NET   158 = abc_1402_new_n122
* NET   159 = abc_1402_new_n121
* NET   160 = abc_1402_new_n120
* NET   161 = abc_1402_new_n119
* NET   162 = abc_1402_new_n118
* NET   163 = abc_1402_new_n117
* NET   164 = abc_1402_new_n116
* NET   165 = abc_1402_new_n115
* NET   166 = abc_1402_new_n114
* NET   167 = abc_1402_new_n113
* NET   168 = abc_1402_new_n112
* NET   169 = abc_1402_new_n111
* NET   170 = abc_1402_new_n110
* NET   171 = abc_1402_new_n109
* NET   172 = abc_1402_new_n108
* NET   173 = abc_1402_new_n107
* NET   174 = abc_1402_new_n106
* NET   175 = abc_1402_new_n105
* NET   176 = abc_1402_new_n104
* NET   177 = abc_1402_new_n103
* NET   178 = abc_1402_new_n102
* NET   179 = abc_1402_new_n101
* NET   180 = abc_1402_new_n100
* NET   181 = abc_1402_auto_rtlil_cc_2739_MuxGate_1401
* NET   182 = abc_1402_auto_rtlil_cc_2739_MuxGate_1399
* NET   183 = abc_1402_auto_rtlil_cc_2739_MuxGate_1397
* NET   184 = abc_1402_auto_rtlil_cc_2739_MuxGate_1395
* NET   185 = abc_1402_auto_rtlil_cc_2739_MuxGate_1393
* NET   186 = abc_1402_auto_rtlil_cc_2739_MuxGate_1391
* NET   187 = abc_1402_auto_rtlil_cc_2739_MuxGate_1389
* NET   188 = abc_1402_auto_rtlil_cc_2739_MuxGate_1387
* NET   189 = abc_1402_auto_rtlil_cc_2739_MuxGate_1385
* NET   190 = abc_1402_auto_rtlil_cc_2739_MuxGate_1383
* NET   191 = abc_1402_auto_rtlil_cc_2739_MuxGate_1381
* NET   192 = abc_1402_auto_rtlil_cc_2739_MuxGate_1379
* NET   193 = abc_1402_auto_rtlil_cc_2739_MuxGate_1377
* NET   194 = abc_1402_auto_rtlil_cc_2739_MuxGate_1375
* NET   195 = abc_1402_auto_rtlil_cc_2739_MuxGate_1373
* NET   196 = abc_1402_auto_rtlil_cc_2739_MuxGate_1371
* NET   197 = abc_1402_auto_rtlil_cc_2739_MuxGate_1369
* NET   198 = abc_1402_auto_rtlil_cc_2739_MuxGate_1367
* NET   199 = abc_1402_auto_rtlil_cc_2739_MuxGate_1365
* NET   200 = abc_1402_auto_rtlil_cc_2739_MuxGate_1363
* NET   201 = abc_1402_auto_rtlil_cc_2739_MuxGate_1361
* NET   202 = abc_1402_auto_rtlil_cc_2739_MuxGate_1359
* NET   203 = abc_1402_auto_rtlil_cc_2739_MuxGate_1357
* NET   204 = abc_1402_auto_rtlil_cc_2739_MuxGate_1355
* NET   205 = abc_1402_auto_rtlil_cc_2739_MuxGate_1353
* NET   206 = abc_1402_auto_rtlil_cc_2739_MuxGate_1351
* NET   207 = abc_1402_auto_rtlil_cc_2739_MuxGate_1349
* NET   208 = abc_1402_auto_rtlil_cc_2739_MuxGate_1347
* NET   209 = abc_1402_auto_rtlil_cc_2739_MuxGate_1345
* NET   210 = abc_1402_auto_rtlil_cc_2739_MuxGate_1343
* NET   211 = abc_1402_auto_rtlil_cc_2739_MuxGate_1341
* NET   212 = abc_1402_auto_rtlil_cc_2739_MuxGate_1339
* NET   213 = abc_1402_auto_rtlil_cc_2739_MuxGate_1337
* NET   214 = abc_1402_auto_rtlil_cc_2739_MuxGate_1335
* NET   215 = abc_1402_auto_rtlil_cc_2739_MuxGate_1333
* NET   216 = abc_1402_auto_rtlil_cc_2739_MuxGate_1331
* NET   217 = abc_1402_auto_rtlil_cc_2739_MuxGate_1329
* NET   218 = abc_1402_auto_rtlil_cc_2739_MuxGate_1327
* NET   219 = abc_1402_auto_rtlil_cc_2739_MuxGate_1325
* NET   220 = abc_1402_auto_rtlil_cc_2739_MuxGate_1323

xsubckt_94_and3_x1 1 0 113 35 33 34 and3_x1
xsubckt_81_and2_x1 1 0 121 122 38 and2_x1
xsubckt_118_and4_x1 1 0 95 98 129 27 26 and4_x1
xsubckt_83_nexor2_x0 1 0 121 168 207 nexor2_x0
xsubckt_62_and3_x1 1 0 132 134 136 16 and3_x1
xsubckt_125_and4_x1 1 0 91 93 96 26 23 and4_x1
xsubckt_65_nexor2_x0 1 0 132 159 215 nexor2_x0
xsubckt_112_and3_x1 1 0 99 103 110 113 and3_x1
xsubckt_56_nexor2_x0 1 0 137 41 219 nexor2_x0
xsubckt_140_nand4_x0 1 0 83 139 44 65 55 nand4_x0
xsubckt_160_nand2_x0 1 0 68 53 66 nand2_x0
xsubckt_39_and4_x1 1 0 151 152 153 154 155 and4_x1
xsubckt_30_inv_x0 1 0 42 156 inv_x0
xsubckt_68_nexor2_x0 1 0 130 162 214 nexor2_x0
xsubckt_162_nand3_x0 1 0 182 67 68 69 nand3_x0
xsubckt_180_dff_x1 1 0 204 56 34 dff_x1
xsubckt_181_dff_x1 1 0 203 56 33 dff_x1
xsubckt_182_dff_x1 1 0 202 56 32 dff_x1
xsubckt_183_dff_x1 1 0 201 56 31 dff_x1
xsubckt_102_and2_x1 1 0 108 35 32 and2_x1
xsubckt_97_nand4_x0 1 0 111 115 33 34 32 nand4_x0
xsubckt_184_dff_x1 1 0 200 56 29 dff_x1
xsubckt_185_dff_x1 1 0 199 56 28 dff_x1
xsubckt_186_dff_x1 1 0 198 57 27 dff_x1
xsubckt_187_dff_x1 1 0 197 56 26 dff_x1
xsubckt_188_dff_x1 1 0 196 56 25 dff_x1
xsubckt_189_dff_x1 1 0 195 57 24 dff_x1
xsubckt_130_nexor2_x0 1 0 90 63 192 nexor2_x0
xsubckt_121_nexor2_x0 1 0 95 178 196 nexor2_x0
xsubckt_98_nexor2_x0 1 0 112 173 202 nexor2_x0
xsubckt_89_nexor2_x0 1 0 118 170 206 nexor2_x0
xsubckt_149_nand2_x0 1 0 76 50 66 nand2_x0
xsubckt_135_nand4_x0 1 0 87 139 43 65 55 nand4_x0
xsubckt_74_nand4_x0 1 0 125 126 130 13 14 nand4_x0
xsubckt_133_nexor2_x0 1 0 88 64 190 nexor2_x0
xsubckt_110_and4_x1 1 0 101 102 104 120 124 and4_x1
xsubckt_32_xor2_x0 1 0 44 5 4 xor2_x0
xsubckt_159_nand4_x0 1 0 69 140 141 8 55 nand4_x0
xsubckt_108_and2_x1 1 0 103 29 28 and2_x1
xsubckt_106_nexor2_x0 1 0 106 174 200 nexor2_x0
xsubckt_105_nand3_x0 1 0 105 107 116 29 nand3_x0
xsubckt_37_nor4_x0 1 0 153 19 30 15 16 nor4_x0
xsubckt_4_inv_x0 1 0 20 62 inv_x0
xsubckt_3_inv_x0 1 0 21 63 inv_x0
xsubckt_2_inv_x0 1 0 18 64 inv_x0
xsubckt_1_inv_x0 1 0 17 65 inv_x0
xsubckt_0_inv_x0 1 0 55 66 inv_x0
xsubckt_46_nand4_x0 1 0 144 146 147 148 149 nand4_x0
xsubckt_158_nand3_x0 1 0 183 70 71 72 nand3_x0
xsubckt_109_and4_x1 1 0 102 32 31 29 28 and4_x1
xsubckt_9_inv_x0 1 0 26 177 inv_x0
xsubckt_8_inv_x0 1 0 25 178 inv_x0
xsubckt_7_inv_x0 1 0 24 179 inv_x0
xsubckt_6_inv_x0 1 0 23 180 inv_x0
xsubckt_5_inv_x0 1 0 22 61 inv_x0
xsubckt_44_nor4_x0 1 0 146 32 31 29 28 nor4_x0
xsubckt_122_and2_x1 1 0 93 25 24 and2_x1
xsubckt_66_and4_x1 1 0 130 131 143 17 55 and4_x1
xfeed_10 1 0 decap_w0
xfeed_11 1 0 tie
xfeed_12 1 0 tie
xfeed_13 1 0 tie
xfeed_14 1 0 tie
xfeed_15 1 0 decap_w0
xfeed_16 1 0 tie
xfeed_17 1 0 tie
xfeed_18 1 0 tie
xfeed_19 1 0 decap_w0
xsubckt_116_and4_x1 1 0 96 101 130 14 27 and4_x1
xsubckt_115_and21nor_x0 1 0 199 175 105 97 and21nor_x0
xsubckt_137_nand4_x0 1 0 85 140 141 2 55 nand4_x0
xsubckt_88_and3_x1 1 0 116 117 130 14 and3_x1
xsubckt_72_nexor2_x0 1 0 128 163 212 nexor2_x0
xfeed_20 1 0 decap_w0
xfeed_21 1 0 decap_w0
xfeed_22 1 0 decap_w0
xfeed_23 1 0 decap_w0
xfeed_24 1 0 decap_w0
xfeed_25 1 0 decap_w0
xfeed_26 1 0 decap_w0
xfeed_27 1 0 decap_w0
xfeed_28 1 0 decap_w0
xfeed_29 1 0 decap_w0
xsubckt_157_nand2_x0 1 0 70 52 66 nand2_x0
xsubckt_143_nand4_x0 1 0 81 139 45 65 55 nand4_x0
xsubckt_51_nand3_x0 1 0 139 142 145 151 nand3_x0
xsubckt_54_nexor2_x0 1 0 138 156 220 nexor2_x0
xsubckt_63_nexor2_x0 1 0 133 160 216 nexor2_x0
xsubckt_95_and3_x1 1 0 112 115 33 34 and3_x1
xsubckt_93_nexor2_x0 1 0 115 172 204 nexor2_x0
xsubckt_53_nand4_x0 1 0 137 140 141 42 55 nand4_x0
xfeed_30 1 0 decap_w0
xfeed_31 1 0 decap_w0
xfeed_32 1 0 decap_w0
xfeed_33 1 0 decap_w0
xfeed_34 1 0 tie
xfeed_35 1 0 tie
xfeed_36 1 0 tie
xfeed_37 1 0 tie
xfeed_38 1 0 tie
xfeed_39 1 0 tie
xsubckt_76_and4_x1 1 0 124 13 12 11 40 and4_x1
xsubckt_200_dff_x1 1 0 185 57 46 dff_x1
xsubckt_201_dff_x1 1 0 184 57 3 dff_x1
xsubckt_10_inv_x0 1 0 27 176 inv_x0
xsubckt_11_inv_x0 1 0 28 175 inv_x0
xsubckt_12_inv_x0 1 0 29 174 inv_x0
xsubckt_13_inv_x0 1 0 32 173 inv_x0
xsubckt_14_inv_x0 1 0 34 172 inv_x0
xsubckt_75_nexor2_x0 1 0 127 164 211 nexor2_x0
xsubckt_202_dff_x1 1 0 183 57 5 dff_x1
xsubckt_203_dff_x1 1 0 182 57 7 dff_x1
xsubckt_204_dff_x1 1 0 181 57 9 dff_x1
xfeed_40 1 0 tie
xfeed_41 1 0 decap_w0
xfeed_42 1 0 decap_w0
xfeed_43 1 0 tie
xfeed_44 1 0 decap_w0
xfeed_45 1 0 decap_w0
xfeed_46 1 0 tie
xsubckt_142_nand3_x0 1 0 187 82 83 84 nand3_x0
xsubckt_113_and3_x1 1 0 98 99 119 36 and3_x1
xsubckt_15_inv_x0 1 0 33 171 inv_x0
xsubckt_16_inv_x0 1 0 36 170 inv_x0
xsubckt_17_inv_x0 1 0 35 169 inv_x0
xsubckt_18_inv_x0 1 0 37 168 inv_x0
xsubckt_19_inv_x0 1 0 38 167 inv_x0
xfeed_47 1 0 tie
xfeed_48 1 0 tie
xfeed_49 1 0 tie
xsubckt_100_and2_x1 1 0 110 32 31 and2_x1
xsubckt_96_nexor2_x0 1 0 114 171 203 nexor2_x0
xsubckt_85_and2_x1 1 0 119 120 124 and2_x1
xsubckt_164_dff_x1 1 0 220 58 42 dff_x1
xsubckt_165_dff_x1 1 0 219 58 41 dff_x1
xsubckt_166_dff_x1 1 0 218 58 30 dff_x1
xsubckt_167_dff_x1 1 0 217 58 19 dff_x1
xsubckt_168_dff_x1 1 0 216 58 16 dff_x1
xsubckt_169_dff_x1 1 0 215 58 15 dff_x1
xfeed_50 1 0 tie
xfeed_51 1 0 tie
xfeed_52 1 0 tie
xfeed_53 1 0 tie
xfeed_109 1 0 decap_w0
xfeed_108 1 0 decap_w0
xfeed_107 1 0 decap_w0
xfeed_106 1 0 decap_w0
xfeed_105 1 0 decap_w0
xsubckt_90_and4_x1 1 0 115 117 130 14 35 and4_x1
xsubckt_79_and4_x1 1 0 122 124 130 14 39 and4_x1
xfeed_54 1 0 tie
xfeed_55 1 0 decap_w0
xfeed_56 1 0 tie
xfeed_57 1 0 tie
xfeed_58 1 0 tie
xfeed_59 1 0 tie
xfeed_100 1 0 tie
xfeed_101 1 0 decap_w0
xfeed_102 1 0 tie
xfeed_103 1 0 decap_w0
xfeed_104 1 0 decap_w0
xsubckt_92_and2_x1 1 0 114 115 34 and2_x1
xsubckt_190_dff_x1 1 0 194 56 23 dff_x1
xfeed_60 1 0 tie
xfeed_119 1 0 tie
xfeed_118 1 0 decap_w0
xfeed_117 1 0 tie
xfeed_116 1 0 decap_w0
xfeed_115 1 0 decap_w0
xfeed_114 1 0 tie
xfeed_113 1 0 tie
xfeed_112 1 0 tie
xfeed_111 1 0 tie
xfeed_110 1 0 decap_w0
xsubckt_141_nand2_x0 1 0 82 48 66 nand2_x0
xsubckt_103_and2_x1 1 0 107 108 109 and2_x1
xsubckt_191_dff_x1 1 0 193 58 22 dff_x1
xsubckt_192_dff_x1 1 0 192 56 21 dff_x1
xsubckt_193_dff_x1 1 0 191 58 20 dff_x1
xsubckt_194_dff_x1 1 0 190 58 18 dff_x1
xsubckt_195_dff_x1 1 0 189 58 17 dff_x1
xsubckt_196_dff_x1 1 0 10 57 55 dff_x1
xfeed_61 1 0 tie
xfeed_62 1 0 tie
xfeed_63 1 0 tie
xfeed_64 1 0 tie
xfeed_65 1 0 tie
xfeed_66 1 0 decap_w0
xfeed_67 1 0 decap_w0
xfeed_68 1 0 decap_w0
xfeed_69 1 0 decap_w0
xsubckt_99_nexor2_x0 1 0 111 31 201 nexor2_x0
xsubckt_60_and2_x1 1 0 133 134 136 and2_x1
xsubckt_78_and21nor_x0 1 0 210 166 125 123 and21nor_x0
xsubckt_197_dff_x1 1 0 188 58 43 dff_x1
xsubckt_198_dff_x1 1 0 187 58 44 dff_x1
xsubckt_199_dff_x1 1 0 186 57 45 dff_x1
xfeed_129 1 0 tie
xfeed_128 1 0 tie
xfeed_127 1 0 tie
xfeed_126 1 0 tie
xfeed_125 1 0 tie
xfeed_124 1 0 tie
xfeed_123 1 0 decap_w0
xfeed_122 1 0 tie
xfeed_121 1 0 decap_w0
xfeed_120 1 0 tie
xsubckt_139_nand4_x0 1 0 84 140 141 3 55 nand4_x0
xsubckt_123_and3_x1 1 0 92 93 96 26 and3_x1
xsubckt_50_or21nand_x0 1 0 140 144 150 65 or21nand_x0
xsubckt_69_and3_x1 1 0 128 130 13 14 and3_x1
xfeed_70 1 0 tie
xfeed_71 1 0 tie
xfeed_72 1 0 tie
xfeed_73 1 0 tie
xfeed_74 1 0 tie
xfeed_75 1 0 tie
xfeed_76 1 0 tie
xfeed_77 1 0 tie
xfeed_78 1 0 decap_w0
xfeed_79 1 0 tie
xsubckt_151_nand4_x0 1 0 75 139 3 65 55 nand4_x0
xsubckt_145_nand4_x0 1 0 79 140 141 4 55 nand4_x0
xsubckt_120_nand3_x0 1 0 94 96 26 25 nand3_x0
xfeed_139 1 0 tie
xfeed_138 1 0 tie
xfeed_137 1 0 tie
xfeed_136 1 0 tie
xfeed_135 1 0 decap_w0
xfeed_134 1 0 tie
xfeed_133 1 0 tie
xfeed_132 1 0 tie
xfeed_131 1 0 tie
xfeed_130 1 0 tie
xsubckt_41_nor2_x0 1 0 149 18 17 nor2_x0
xfeed_80 1 0 decap_w0
xfeed_81 1 0 decap_w0
xfeed_82 1 0 decap_w0
xfeed_83 1 0 tie
xfeed_84 1 0 decap_w0
xfeed_85 1 0 decap_w0
xfeed_86 1 0 decap_w0
xfeed_87 1 0 decap_w0
xfeed_88 1 0 decap_w0
xfeed_89 1 0 tie
xsubckt_136_nand2_x0 1 0 86 47 66 nand2_x0
xsubckt_35_nor4_x0 1 0 155 35 36 33 34 nor4_x0
xsubckt_33_xor2_x0 1 0 45 7 6 xor2_x0
xfeed_149 1 0 tie
xfeed_148 1 0 tie
xfeed_147 1 0 decap_w0
xfeed_146 1 0 tie
xfeed_145 1 0 tie
xfeed_144 1 0 tie
xfeed_143 1 0 tie
xfeed_142 1 0 decap_w0
xfeed_141 1 0 tie
xfeed_140 1 0 tie
xsubckt_138_nand3_x0 1 0 188 85 86 87 nand3_x0
xsubckt_59_and2_x1 1 0 134 19 30 and2_x1
xfeed_90 1 0 decap_w0
xfeed_91 1 0 decap_w0
xfeed_92 1 0 tie
xfeed_93 1 0 tie
xfeed_94 1 0 tie
xfeed_95 1 0 tie
xfeed_96 1 0 tie
xfeed_97 1 0 tie
xfeed_98 1 0 decap_w0
xfeed_99 1 0 decap_w0
xsubckt_150_nand3_x0 1 0 185 76 77 78 nand3_x0
xsubckt_107_and4_x1 1 0 104 35 36 33 34 and4_x1
xsubckt_42_nor4_x0 1 0 148 23 22 20 21 nor4_x0
xfeed_159 1 0 decap_w0
xfeed_158 1 0 decap_w0
xfeed_157 1 0 tie
xfeed_156 1 0 tie
xfeed_155 1 0 tie
xfeed_154 1 0 tie
xfeed_153 1 0 tie
xfeed_152 1 0 tie
xfeed_151 1 0 tie
xfeed_150 1 0 tie
xsubckt_124_and21nor_x0 1 0 195 179 94 92 and21nor_x0
xsubckt_64_and4_x1 1 0 131 19 30 15 16 and4_x1
xsubckt_129_and3_x1 1 0 89 91 22 21 and3_x1
xsubckt_86_and3_x1 1 0 118 119 130 14 and3_x1
xsubckt_38_nor4_x0 1 0 152 13 14 12 11 nor4_x0
xfeed_169 1 0 tie
xfeed_168 1 0 tie
xfeed_167 1 0 tie
xfeed_166 1 0 tie
xfeed_165 1 0 tie
xfeed_164 1 0 tie
xfeed_163 1 0 decap_w0
xfeed_162 1 0 decap_w0
xfeed_161 1 0 tie
xfeed_160 1 0 tie
xsubckt_128_nexor2_x0 1 0 91 61 193 nexor2_x0
xsubckt_101_and3_x1 1 0 109 33 34 31 and3_x1
xsubckt_61_nexor2_x0 1 0 135 157 217 nexor2_x0
xsubckt_70_nexor2_x0 1 0 129 161 213 nexor2_x0
xsubckt_71_and4_x1 1 0 127 130 13 14 12 and4_x1
xsubckt_73_and2_x1 1 0 126 12 11 and2_x1
xsubckt_119_nexor2_x0 1 0 96 177 197 nexor2_x0
xfeed_179 1 0 tie
xfeed_178 1 0 tie
xfeed_177 1 0 tie
xfeed_176 1 0 decap_w0
xfeed_175 1 0 tie
xfeed_174 1 0 decap_w0
xfeed_173 1 0 tie
xfeed_172 1 0 tie
xfeed_171 1 0 decap_w0
xfeed_170 1 0 tie
xsubckt_91_nexor2_x0 1 0 116 169 205 nexor2_x0
xcmpt_one_0 1 0 10 one_x1
xsubckt_82_nexor2_x0 1 0 122 167 208 nexor2_x0
xfeed_189 1 0 decap_w0
xfeed_188 1 0 decap_w0
xfeed_187 1 0 decap_w0
xfeed_186 1 0 decap_w0
xfeed_185 1 0 decap_w0
xfeed_184 1 0 decap_w0
xfeed_183 1 0 decap_w0
xfeed_182 1 0 decap_w0
xfeed_181 1 0 decap_w0
xfeed_180 1 0 tie
xsubckt_153_nand4_x0 1 0 73 140 141 6 55 nand4_x0
xsubckt_147_nand4_x0 1 0 78 139 46 65 55 nand4_x0
xsubckt_49_nand3_x0 1 0 141 143 145 151 nand3_x0
xsubckt_111_and3_x1 1 0 100 101 130 14 and3_x1
xfeed_194 1 0 decap_w0
xfeed_193 1 0 decap_w0
xfeed_192 1 0 decap_w0
xfeed_191 1 0 decap_w0
xfeed_190 1 0 decap_w0
xsubckt_144_nand2_x0 1 0 80 49 66 nand2_x0
xsubckt_134_and21nor_x0 1 0 189 88 18 65 and21nor_x0
xsubckt_131_and4_x1 1 0 88 91 22 20 21 and4_x1
xsubckt_21_inv_x0 1 0 39 165 inv_x0
xsubckt_20_inv_x0 1 0 40 166 inv_x0
xspare_buffer_0 1 0 59 58 buf_x4
xspare_buffer_1 1 0 57 buf_x4
xspare_buffer_2 1 0 56 buf_x4
xsubckt_146_nand3_x0 1 0 186 79 80 81 nand3_x0
xsubckt_127_and4_x1 1 0 90 93 95 23 22 and4_x1
xsubckt_40_nand4_x0 1 0 150 152 153 154 155 nand4_x0
xsubckt_26_inv_x0 1 0 16 160 inv_x0
xsubckt_25_inv_x0 1 0 13 161 inv_x0
xsubckt_24_inv_x0 1 0 14 162 inv_x0
xsubckt_23_inv_x0 1 0 12 163 inv_x0
xsubckt_22_inv_x0 1 0 11 164 inv_x0
xsubckt_48_nand2_x0 1 0 142 42 41 nand2_x0
xsubckt_170_dff_x1 1 0 214 56 14 dff_x1
xfeed_0 1 0 decap_w0
xsubckt_148_nand4_x0 1 0 77 140 141 5 55 nand4_x0
xsubckt_29_inv_x0 1 0 19 157 inv_x0
xsubckt_28_inv_x0 1 0 30 158 inv_x0
xsubckt_27_inv_x0 1 0 15 159 inv_x0
xsubckt_45_and4_x1 1 0 145 146 147 148 149 and4_x1
xsubckt_47_and2_x1 1 0 143 42 41 and2_x1
xsubckt_58_nexor2_x0 1 0 136 158 218 nexor2_x0
xsubckt_171_dff_x1 1 0 213 57 13 dff_x1
xsubckt_172_dff_x1 1 0 212 57 12 dff_x1
xsubckt_173_dff_x1 1 0 211 57 11 dff_x1
xsubckt_174_dff_x1 1 0 210 57 40 dff_x1
xsubckt_175_dff_x1 1 0 209 57 39 dff_x1
xsubckt_176_dff_x1 1 0 208 57 38 dff_x1
xfeed_1 1 0 decap_w0
xfeed_2 1 0 decap_w0
xfeed_3 1 0 decap_w0
xfeed_4 1 0 decap_w0
xfeed_5 1 0 decap_w0
xfeed_6 1 0 decap_w0
xfeed_7 1 0 decap_w0
xfeed_8 1 0 decap_w0
xfeed_9 1 0 decap_w0
xsubckt_163_mux2_x1 1 0 54 9 55 181 mux2_x1
xsubckt_177_dff_x1 1 0 207 57 37 dff_x1
xsubckt_178_dff_x1 1 0 206 56 36 dff_x1
xsubckt_179_dff_x1 1 0 205 56 35 dff_x1
xsubckt_104_and2_x1 1 0 106 107 116 and2_x1
xsubckt_132_nexor2_x0 1 0 89 62 191 nexor2_x0
xsubckt_31_xor2_x0 1 0 43 3 2 xor2_x0
xsubckt_155_nand4_x0 1 0 72 139 5 65 55 nand4_x0
xsubckt_55_and4_x1 1 0 136 42 41 17 55 and4_x1
xsubckt_57_and2_x1 1 0 135 136 30 and2_x1
xsubckt_77_and3_x1 1 0 123 124 130 14 and3_x1
xsubckt_161_nand4_x0 1 0 67 139 7 65 55 nand4_x0
xsubckt_152_nand2_x0 1 0 74 51 66 nand2_x0
xsubckt_114_and2_x1 1 0 97 98 129 and2_x1
xsubckt_84_and3_x1 1 0 120 39 38 37 and3_x1
xsubckt_36_nor4_x0 1 0 154 39 40 38 37 nor4_x0
xsubckt_34_xor2_x0 1 0 46 9 8 xor2_x0
xspare_feed_0 1 0 tie
xspare_feed_1 1 0 tie
xspare_feed_2 1 0 tie
xspare_feed_3 1 0 tie
xspare_feed_4 1 0 decap_w0
xspare_feed_5 1 0 tie
xspare_feed_6 1 0 tie
xsubckt_154_nand3_x0 1 0 184 73 74 75 nand3_x0
xsubckt_126_nexor2_x0 1 0 92 180 194 nexor2_x0
xsubckt_117_nexor2_x0 1 0 100 176 198 nexor2_x0
xsubckt_43_nor4_x0 1 0 147 27 26 25 24 nor4_x0
xsubckt_67_and2_x1 1 0 129 130 14 and2_x1
xsubckt_156_nand4_x0 1 0 71 140 141 7 55 nand4_x0
xsubckt_87_and3_x1 1 0 117 120 124 36 and3_x1
xsubckt_52_and21nor_x0 1 0 138 139 65 66 and21nor_x0
xsubckt_80_nexor2_x0 1 0 123 165 209 nexor2_x0
.ends expmob2_cts_r
