* Coriolis Structural SPICE Driver
* Generated on Apr 15, 2025, 15:38
* Cell/Subckt "expmob2".
*
* INTERF vss
* INTERF vdd
* INTERF outputs[9]
* INTERF outputs[8]
* INTERF outputs[7]
* INTERF outputs[6]
* INTERF outputs[5]
* INTERF outputs[4]
* INTERF outputs[31]
* INTERF outputs[30]
* INTERF outputs[3]
* INTERF outputs[29]
* INTERF outputs[28]
* INTERF outputs[27]
* INTERF outputs[26]
* INTERF outputs[25]
* INTERF outputs[24]
* INTERF outputs[23]
* INTERF outputs[22]
* INTERF outputs[21]
* INTERF outputs[20]
* INTERF outputs[2]
* INTERF outputs[19]
* INTERF outputs[18]
* INTERF outputs[17]
* INTERF outputs[16]
* INTERF outputs[15]
* INTERF outputs[14]
* INTERF outputs[13]
* INTERF outputs[12]
* INTERF outputs[11]
* INTERF outputs[10]
* INTERF outputs[1]
* INTERF outputs[0]
* INTERF inputs[9]
* INTERF inputs[8]
* INTERF inputs[7]
* INTERF inputs[6]
* INTERF inputs[5]
* INTERF inputs[4]
* INTERF inputs[31]
* INTERF inputs[30]
* INTERF inputs[3]
* INTERF inputs[29]
* INTERF inputs[28]
* INTERF inputs[27]
* INTERF inputs[26]
* INTERF inputs[25]
* INTERF inputs[24]
* INTERF inputs[23]
* INTERF inputs[22]
* INTERF inputs[21]
* INTERF inputs[20]
* INTERF inputs[2]
* INTERF inputs[19]
* INTERF inputs[18]
* INTERF inputs[17]
* INTERF inputs[16]
* INTERF inputs[15]
* INTERF inputs[14]
* INTERF inputs[13]
* INTERF inputs[12]
* INTERF inputs[11]
* INTERF inputs[10]
* INTERF inputs[1]
* INTERF inputs[0]
* INTERF clk

* Terminal models (aka standard cells) used througout all the hierarchy.
.include and3_x1.spi
.include and2_x1.spi
.include nand2_x0.spi
.include or3_x1.spi
.include nand3_x0.spi
.include nexor2_x0.spi
.include nor4_x0.spi
.include and4_x1.spi
.include and21nor_x0.spi
.include nand4_x0.spi
.include dff_x1.spi
.include xor2_x0.spi
.include inv_x0.spi
.include mux2_x1.spi
.include nor2_x0.spi
.include or21nand_x0.spi
.include one_x1.spi

* Non-terminal models (part of the user's design hierarchy).

.subckt expmob2 0 1 2 3 4 5 6 7 8 9 10 11 12 13 14 15 16 17 18 19 20 21 22 23 24 25 26 27 28 29 30 31 32 33 83 84 85 86 87 88 89 90 91 92 93 94 95 96 97 98 99 100 101 102 103 104 105 106 107 108 109 110 111 112 113 114 116
* NET     0 = vss
* NET     1 = vdd
* NET     2 = outputs[9]
* NET     3 = outputs[8]
* NET     4 = outputs[7]
* NET     5 = outputs[6]
* NET     6 = outputs[5]
* NET     7 = outputs[4]
* NET     8 = outputs[31]
* NET     9 = outputs[30]
* NET    10 = outputs[3]
* NET    11 = outputs[29]
* NET    12 = outputs[28]
* NET    13 = outputs[27]
* NET    14 = outputs[26]
* NET    15 = outputs[25]
* NET    16 = outputs[24]
* NET    17 = outputs[23]
* NET    18 = outputs[22]
* NET    19 = outputs[21]
* NET    20 = outputs[20]
* NET    21 = outputs[2]
* NET    22 = outputs[19]
* NET    23 = outputs[18]
* NET    24 = outputs[17]
* NET    25 = outputs[16]
* NET    26 = outputs[15]
* NET    27 = outputs[14]
* NET    28 = outputs[13]
* NET    29 = outputs[12]
* NET    30 = outputs[11]
* NET    31 = outputs[10]
* NET    32 = outputs[1]
* NET    33 = outputs[0]
* NET    34 = one_0
* NET    35 = n[9]
* NET    36 = n[8]
* NET    37 = n[7]
* NET    38 = n[6]
* NET    39 = n[5]
* NET    40 = n[4]
* NET    41 = n[31]
* NET    42 = n[30]
* NET    43 = n[3]
* NET    44 = n[29]
* NET    45 = n[28]
* NET    46 = n[27]
* NET    47 = n[26]
* NET    48 = n[25]
* NET    49 = n[24]
* NET    50 = n[23]
* NET    51 = n[22]
* NET    52 = n[21]
* NET    53 = n[20]
* NET    54 = n[2]
* NET    55 = n[19]
* NET    56 = n[18]
* NET    57 = n[17]
* NET    58 = n[16]
* NET    59 = n[15]
* NET    60 = n[14]
* NET    61 = n[13]
* NET    62 = n[12]
* NET    63 = n[11]
* NET    64 = n[10]
* NET    65 = n[1]
* NET    66 = n[0]
* NET    67 = mem_inputs[31]
* NET    68 = mem_inputs[30]
* NET    69 = mem_inputs[29]
* NET    70 = mem_inputs[28]
* NET    71 = mem_inputs[27]
* NET    72 = mem_inputs[26]
* NET    73 = mem_inputs[25]
* NET    74 = mem_inputs[24]
* NET    75 = mem_inputs[23]
* NET    76 = mem_inputs[22]
* NET    77 = mem_inputs[21]
* NET    78 = mem_inputs[20]
* NET    79 = mem_inputs[19]
* NET    80 = mem_inputs[18]
* NET    81 = mem_inputs[17]
* NET    82 = mem_inputs[16]
* NET    83 = inputs[9]
* NET    84 = inputs[8]
* NET    85 = inputs[7]
* NET    86 = inputs[6]
* NET    87 = inputs[5]
* NET    88 = inputs[4]
* NET    89 = inputs[31]
* NET    90 = inputs[30]
* NET    91 = inputs[3]
* NET    92 = inputs[29]
* NET    93 = inputs[28]
* NET    94 = inputs[27]
* NET    95 = inputs[26]
* NET    96 = inputs[25]
* NET    97 = inputs[24]
* NET    98 = inputs[23]
* NET    99 = inputs[22]
* NET   100 = inputs[21]
* NET   101 = inputs[20]
* NET   102 = inputs[2]
* NET   103 = inputs[19]
* NET   104 = inputs[18]
* NET   105 = inputs[17]
* NET   106 = inputs[16]
* NET   107 = inputs[15]
* NET   108 = inputs[14]
* NET   109 = inputs[13]
* NET   110 = inputs[12]
* NET   111 = inputs[11]
* NET   112 = inputs[10]
* NET   113 = inputs[1]
* NET   114 = inputs[0]
* NET   115 = init
* NET   116 = clk
* NET   117 = abc_1574_new_n443
* NET   118 = abc_1574_new_n441
* NET   119 = abc_1574_new_n439
* NET   120 = abc_1574_new_n437
* NET   121 = abc_1574_new_n435
* NET   122 = abc_1574_new_n434
* NET   123 = abc_1574_new_n433
* NET   124 = abc_1574_new_n432
* NET   125 = abc_1574_new_n429
* NET   126 = abc_1574_new_n428
* NET   127 = abc_1574_new_n427
* NET   128 = abc_1574_new_n424
* NET   129 = abc_1574_new_n422
* NET   130 = abc_1574_new_n421
* NET   131 = abc_1574_new_n419
* NET   132 = abc_1574_new_n418
* NET   133 = abc_1574_new_n417
* NET   134 = abc_1574_new_n415
* NET   135 = abc_1574_new_n413
* NET   136 = abc_1574_new_n411
* NET   137 = abc_1574_new_n410
* NET   138 = abc_1574_new_n408
* NET   139 = abc_1574_new_n406
* NET   140 = abc_1574_new_n404
* NET   141 = abc_1574_new_n402
* NET   142 = abc_1574_new_n401
* NET   143 = abc_1574_new_n400
* NET   144 = abc_1574_new_n399
* NET   145 = abc_1574_new_n397
* NET   146 = abc_1574_new_n396
* NET   147 = abc_1574_new_n394
* NET   148 = abc_1574_new_n393
* NET   149 = abc_1574_new_n391
* NET   150 = abc_1574_new_n390
* NET   151 = abc_1574_new_n389
* NET   152 = abc_1574_new_n386
* NET   153 = abc_1574_new_n384
* NET   154 = abc_1574_new_n382
* NET   155 = abc_1574_new_n381
* NET   156 = abc_1574_new_n380
* NET   157 = abc_1574_new_n378
* NET   158 = abc_1574_new_n376
* NET   159 = abc_1574_new_n375
* NET   160 = abc_1574_new_n373
* NET   161 = abc_1574_new_n371
* NET   162 = abc_1574_new_n370
* NET   163 = abc_1574_new_n368
* NET   164 = abc_1574_new_n367
* NET   165 = abc_1574_new_n363
* NET   166 = abc_1574_new_n362
* NET   167 = abc_1574_new_n361
* NET   168 = abc_1574_new_n359
* NET   169 = abc_1574_new_n358
* NET   170 = abc_1574_new_n357
* NET   171 = abc_1574_new_n355
* NET   172 = abc_1574_new_n354
* NET   173 = abc_1574_new_n353
* NET   174 = abc_1574_new_n351
* NET   175 = abc_1574_new_n350
* NET   176 = abc_1574_new_n349
* NET   177 = abc_1574_new_n347
* NET   178 = abc_1574_new_n346
* NET   179 = abc_1574_new_n345
* NET   180 = abc_1574_new_n343
* NET   181 = abc_1574_new_n342
* NET   182 = abc_1574_new_n341
* NET   183 = abc_1574_new_n339
* NET   184 = abc_1574_new_n338
* NET   185 = abc_1574_new_n337
* NET   186 = abc_1574_new_n335
* NET   187 = abc_1574_new_n334
* NET   188 = abc_1574_new_n333
* NET   189 = abc_1574_new_n331
* NET   190 = abc_1574_new_n330
* NET   191 = abc_1574_new_n329
* NET   192 = abc_1574_new_n327
* NET   193 = abc_1574_new_n326
* NET   194 = abc_1574_new_n325
* NET   195 = abc_1574_new_n323
* NET   196 = abc_1574_new_n322
* NET   197 = abc_1574_new_n321
* NET   198 = abc_1574_new_n320
* NET   199 = abc_1574_new_n318
* NET   200 = abc_1574_new_n317
* NET   201 = abc_1574_new_n316
* NET   202 = abc_1574_new_n314
* NET   203 = abc_1574_new_n313
* NET   204 = abc_1574_new_n312
* NET   205 = abc_1574_new_n310
* NET   206 = abc_1574_new_n309
* NET   207 = abc_1574_new_n308
* NET   208 = abc_1574_new_n306
* NET   209 = abc_1574_new_n305
* NET   210 = abc_1574_new_n304
* NET   211 = abc_1574_new_n302
* NET   212 = abc_1574_new_n301
* NET   213 = abc_1574_new_n300
* NET   214 = abc_1574_new_n298
* NET   215 = abc_1574_new_n297
* NET   216 = abc_1574_new_n296
* NET   217 = abc_1574_new_n295
* NET   218 = abc_1574_new_n293
* NET   219 = abc_1574_new_n292
* NET   220 = abc_1574_new_n291
* NET   221 = abc_1574_new_n289
* NET   222 = abc_1574_new_n288
* NET   223 = abc_1574_new_n287
* NET   224 = abc_1574_new_n285
* NET   225 = abc_1574_new_n284
* NET   226 = abc_1574_new_n283
* NET   227 = abc_1574_new_n281
* NET   228 = abc_1574_new_n280
* NET   229 = abc_1574_new_n279
* NET   230 = abc_1574_new_n277
* NET   231 = abc_1574_new_n276
* NET   232 = abc_1574_new_n275
* NET   233 = abc_1574_new_n273
* NET   234 = abc_1574_new_n272
* NET   235 = abc_1574_new_n271
* NET   236 = abc_1574_new_n270
* NET   237 = abc_1574_new_n268
* NET   238 = abc_1574_new_n267
* NET   239 = abc_1574_new_n266
* NET   240 = abc_1574_new_n264
* NET   241 = abc_1574_new_n263
* NET   242 = abc_1574_new_n262
* NET   243 = abc_1574_new_n260
* NET   244 = abc_1574_new_n259
* NET   245 = abc_1574_new_n258
* NET   246 = abc_1574_new_n256
* NET   247 = abc_1574_new_n255
* NET   248 = abc_1574_new_n254
* NET   249 = abc_1574_new_n252
* NET   250 = abc_1574_new_n251
* NET   251 = abc_1574_new_n250
* NET   252 = abc_1574_new_n248
* NET   253 = abc_1574_new_n247
* NET   254 = abc_1574_new_n246
* NET   255 = abc_1574_new_n244
* NET   256 = abc_1574_new_n243
* NET   257 = abc_1574_new_n242
* NET   258 = abc_1574_new_n240
* NET   259 = abc_1574_new_n239
* NET   260 = abc_1574_new_n238
* NET   261 = abc_1574_new_n237
* NET   262 = abc_1574_new_n236
* NET   263 = abc_1574_new_n235
* NET   264 = abc_1574_new_n234
* NET   265 = abc_1574_new_n233
* NET   266 = abc_1574_new_n232
* NET   267 = abc_1574_new_n231
* NET   268 = abc_1574_new_n230
* NET   269 = abc_1574_new_n229
* NET   270 = abc_1574_new_n228
* NET   271 = abc_1574_new_n227
* NET   272 = abc_1574_new_n226
* NET   273 = abc_1574_new_n225
* NET   274 = abc_1574_new_n224
* NET   275 = abc_1574_new_n223
* NET   276 = abc_1574_new_n206
* NET   277 = abc_1574_new_n205
* NET   278 = abc_1574_new_n204
* NET   279 = abc_1574_new_n203
* NET   280 = abc_1574_new_n202
* NET   281 = abc_1574_new_n201
* NET   282 = abc_1574_new_n200
* NET   283 = abc_1574_new_n199
* NET   284 = abc_1574_new_n198
* NET   285 = abc_1574_new_n197
* NET   286 = abc_1574_new_n196
* NET   287 = abc_1574_new_n195
* NET   288 = abc_1574_new_n194
* NET   289 = abc_1574_new_n193
* NET   290 = abc_1574_new_n192
* NET   291 = abc_1574_new_n191
* NET   292 = abc_1574_new_n190
* NET   293 = abc_1574_new_n189
* NET   294 = abc_1574_new_n188
* NET   295 = abc_1574_new_n187
* NET   296 = abc_1574_new_n186
* NET   297 = abc_1574_new_n185
* NET   298 = abc_1574_new_n184
* NET   299 = abc_1574_new_n183
* NET   300 = abc_1574_new_n182
* NET   301 = abc_1574_new_n181
* NET   302 = abc_1574_new_n180
* NET   303 = abc_1574_new_n179
* NET   304 = abc_1574_new_n178
* NET   305 = abc_1574_auto_rtlil_cc_2739_MuxGate_1573
* NET   306 = abc_1574_auto_rtlil_cc_2739_MuxGate_1571
* NET   307 = abc_1574_auto_rtlil_cc_2739_MuxGate_1569
* NET   308 = abc_1574_auto_rtlil_cc_2739_MuxGate_1567
* NET   309 = abc_1574_auto_rtlil_cc_2739_MuxGate_1565
* NET   310 = abc_1574_auto_rtlil_cc_2739_MuxGate_1563
* NET   311 = abc_1574_auto_rtlil_cc_2739_MuxGate_1561
* NET   312 = abc_1574_auto_rtlil_cc_2739_MuxGate_1559
* NET   313 = abc_1574_auto_rtlil_cc_2739_MuxGate_1557
* NET   314 = abc_1574_auto_rtlil_cc_2739_MuxGate_1555
* NET   315 = abc_1574_auto_rtlil_cc_2739_MuxGate_1553
* NET   316 = abc_1574_auto_rtlil_cc_2739_MuxGate_1551
* NET   317 = abc_1574_auto_rtlil_cc_2739_MuxGate_1549
* NET   318 = abc_1574_auto_rtlil_cc_2739_MuxGate_1547
* NET   319 = abc_1574_auto_rtlil_cc_2739_MuxGate_1545
* NET   320 = abc_1574_auto_rtlil_cc_2739_MuxGate_1543
* NET   321 = abc_1574_auto_rtlil_cc_2739_MuxGate_1541
* NET   322 = abc_1574_auto_rtlil_cc_2739_MuxGate_1539
* NET   323 = abc_1574_auto_rtlil_cc_2739_MuxGate_1537
* NET   324 = abc_1574_auto_rtlil_cc_2739_MuxGate_1535
* NET   325 = abc_1574_auto_rtlil_cc_2739_MuxGate_1533
* NET   326 = abc_1574_auto_rtlil_cc_2739_MuxGate_1531
* NET   327 = abc_1574_auto_rtlil_cc_2739_MuxGate_1529
* NET   328 = abc_1574_auto_rtlil_cc_2739_MuxGate_1527
* NET   329 = abc_1574_auto_rtlil_cc_2739_MuxGate_1525
* NET   330 = abc_1574_auto_rtlil_cc_2739_MuxGate_1523
* NET   331 = abc_1574_auto_rtlil_cc_2739_MuxGate_1521
* NET   332 = abc_1574_auto_rtlil_cc_2739_MuxGate_1519
* NET   333 = abc_1574_auto_rtlil_cc_2739_MuxGate_1517
* NET   334 = abc_1574_auto_rtlil_cc_2739_MuxGate_1515
* NET   335 = abc_1574_auto_rtlil_cc_2739_MuxGate_1513
* NET   336 = abc_1574_auto_rtlil_cc_2739_MuxGate_1511
* NET   337 = abc_1574_auto_rtlil_cc_2739_MuxGate_1509
* NET   338 = abc_1574_auto_rtlil_cc_2739_MuxGate_1507
* NET   339 = abc_1574_auto_rtlil_cc_2739_MuxGate_1505
* NET   340 = abc_1574_auto_rtlil_cc_2739_MuxGate_1503
* NET   341 = abc_1574_auto_rtlil_cc_2739_MuxGate_1501
* NET   342 = abc_1574_auto_rtlil_cc_2739_MuxGate_1499
* NET   343 = abc_1574_auto_rtlil_cc_2739_MuxGate_1497
* NET   344 = abc_1574_auto_rtlil_cc_2739_MuxGate_1495
* NET   345 = abc_1574_auto_rtlil_cc_2739_MuxGate_1493
* NET   346 = abc_1574_auto_rtlil_cc_2739_MuxGate_1491
* NET   347 = abc_1574_auto_rtlil_cc_2739_MuxGate_1489
* NET   348 = abc_1574_auto_rtlil_cc_2739_MuxGate_1487
* NET   349 = abc_1574_auto_rtlil_cc_2739_MuxGate_1485
* NET   350 = abc_1574_auto_rtlil_cc_2739_MuxGate_1483
* NET   351 = abc_1574_auto_rtlil_cc_2739_MuxGate_1481
* NET   352 = abc_1574_auto_rtlil_cc_2739_MuxGate_1479
* NET   353 = abc_1574_auto_rtlil_cc_2739_MuxGate_1477
* NET   354 = abc_1574_auto_rtlil_cc_2739_MuxGate_1475
* NET   355 = abc_1574_auto_rtlil_cc_2739_MuxGate_1473
* NET   356 = abc_1574_auto_rtlil_cc_2739_MuxGate_1471
* NET   357 = abc_1574_auto_rtlil_cc_2739_MuxGate_1469
* NET   358 = abc_1574_auto_rtlil_cc_2739_MuxGate_1467
* NET   359 = abc_1574_auto_rtlil_cc_2739_MuxGate_1465
* NET   360 = abc_1574_auto_rtlil_cc_2739_MuxGate_1463
* NET   361 = abc_1574_auto_rtlil_cc_2739_MuxGate_1461
* NET   362 = abc_1574_auto_rtlil_cc_2739_MuxGate_1459
* NET   363 = abc_1574_auto_rtlil_cc_2739_MuxGate_1457
* NET   364 = abc_1574_auto_rtlil_cc_2739_MuxGate_1455
* NET   365 = abc_1574_auto_rtlil_cc_2739_MuxGate_1453
* NET   366 = abc_1574_auto_rtlil_cc_2739_MuxGate_1451
* NET   367 = abc_1574_auto_rtlil_cc_2739_MuxGate_1449
* NET   368 = abc_1574_auto_rtlil_cc_2739_MuxGate_1447

xsubckt_94_and3_x1 1 0 234 263 75 115 and3_x1
xsubckt_81_and2_x1 1 0 244 95 303 and2_x1
xsubckt_144_and3_x1 1 0 196 263 18 115 and3_x1
xsubckt_63_nand2_x0 1 0 368 258 261 nand2_x0
xsubckt_174_or3_x1 1 0 341 174 175 176 or3_x1
xsubckt_131_and2_x1 1 0 206 108 303 and2_x1
xsubckt_105_and3_x1 1 0 226 263 78 115 and3_x1
xsubckt_59_nand3_x0 1 0 261 263 67 115 nand3_x0
xsubckt_77_and2_x1 1 0 247 94 303 and2_x1
xsubckt_179_and3_x1 1 0 170 263 7 115 and3_x1
xsubckt_204_and3_x1 1 0 154 155 262 115 and3_x1
xsubckt_216_nand3_x0 1 0 147 148 262 115 nand3_x0
xsubckt_260_nexor2_x0 1 0 121 299 309 nexor2_x0
xsubckt_127_and2_x1 1 0 209 107 303 and2_x1
xsubckt_126_nand3_x0 1 0 210 263 9 115 nand3_x0
xsubckt_49_nor4_x0 1 0 271 50 49 47 48 nor4_x0
xsubckt_250_and3_x1 1 0 126 127 132 140 and3_x1
xsubckt_97_and3_x1 1 0 232 262 18 115 and3_x1
xsubckt_67_or3_x1 1 0 367 255 256 257 or3_x1
xsubckt_211_and3_x1 1 0 151 37 36 35 and3_x1
xsubckt_242_nexor2_x0 1 0 134 292 316 nexor2_x0
xsubckt_259_and4_x1 1 0 120 123 140 47 46 and4_x1
xsubckt_154_nand2_x0 1 0 346 189 191 nand2_x0
xsubckt_147_and3_x1 1 0 194 262 31 115 and3_x1
xsubckt_128_and21nor_x0 1 0 208 26 259 209 and21nor_x0
xsubckt_87_nand2_x0 1 0 362 240 242 nand2_x0
xsubckt_115_and3_x1 1 0 218 262 23 115 and3_x1
xsubckt_91_or3_x1 1 0 361 237 238 239 or3_x1
xsubckt_180_and2_x1 1 0 169 102 303 and2_x1
xsubckt_193_nand4_x0 1 0 161 164 262 54 115 nand4_x0
xsubckt_240_and2_x1 1 0 132 133 56 and2_x1
xsubckt_102_and2_x1 1 0 228 100 303 and2_x1
xsubckt_62_and21nor_x0 1 0 258 8 259 260 and21nor_x0
xsubckt_72_and3_x1 1 0 251 263 70 115 and3_x1
xsubckt_176_and2_x1 1 0 172 91 303 and2_x1
xsubckt_236_nexor2_x0 1 0 136 290 318 nexor2_x0
xsubckt_122_and3_x1 1 0 213 263 82 115 and3_x1
xsubckt_178_nand2_x0 1 0 340 171 173 nand2_x0
xsubckt_221_and3_x1 1 0 144 148 63 62 and3_x1
xsubckt_227_nexor2_x0 1 0 141 60 322 nexor2_x0
xsubckt_157_and3_x1 1 0 186 262 3 115 and3_x1
xsubckt_153_and21nor_x0 1 0 189 2 259 190 and21nor_x0
xsubckt_53_and4_x1 1 0 267 269 271 272 275 and4_x1
xsubckt_266_nexor2_x0 1 0 118 302 306 nexor2_x0
xsubckt_323_dff_x1 1 0 314 116 51 dff_x1
xsubckt_322_dff_x1 1 0 315 116 52 dff_x1
xsubckt_321_dff_x1 1 0 316 116 53 dff_x1
xsubckt_320_dff_x1 1 0 317 116 55 dff_x1
xsubckt_202_and4_x1 1 0 156 65 39 38 66 and4_x1
xsubckt_209_nexor2_x0 1 0 153 36 328 nexor2_x0
xsubckt_243_and2_x1 1 0 130 53 52 and2_x1
xsubckt_329_dff_x1 1 0 308 116 45 dff_x1
xsubckt_328_dff_x1 1 0 309 116 46 dff_x1
xsubckt_327_dff_x1 1 0 310 116 47 dff_x1
xsubckt_326_dff_x1 1 0 311 116 48 dff_x1
xsubckt_325_dff_x1 1 0 312 116 49 dff_x1
xsubckt_324_dff_x1 1 0 313 116 50 dff_x1
xsubckt_237_and4_x1 1 0 134 137 140 56 55 and4_x1
xsubckt_248_nexor2_x0 1 0 128 295 313 nexor2_x0
xsubckt_263_and3_x1 1 0 118 120 45 44 and3_x1
xsubckt_280_dff_x1 1 0 356 116 79 dff_x1
xsubckt_82_and3_x1 1 0 243 263 72 115 and3_x1
xsubckt_32_xor2_x0 1 0 70 16 15 xor2_x0
xsubckt_71_nand2_x0 1 0 366 252 254 nand2_x0
xsubckt_224_nand3_x0 1 0 141 142 262 115 nand3_x0
xsubckt_281_dff_x1 1 0 355 116 80 dff_x1
xsubckt_282_dff_x1 1 0 354 116 81 dff_x1
xsubckt_283_dff_x1 1 0 353 116 82 dff_x1
xsubckt_284_dff_x1 1 0 352 116 9 dff_x1
xsubckt_285_dff_x1 1 0 351 116 12 dff_x1
xsubckt_286_dff_x1 1 0 350 116 14 dff_x1
xsubckt_134_nand3_x0 1 0 204 263 14 115 nand3_x0
xsubckt_171_and3_x1 1 0 176 263 3 115 and3_x1
xsubckt_287_dff_x1 1 0 349 116 16 dff_x1
xsubckt_288_dff_x1 1 0 348 116 18 dff_x1
xsubckt_289_dff_x1 1 0 347 116 20 dff_x1
xsubckt_132_and3_x1 1 0 205 262 27 115 and3_x1
xsubckt_65_and2_x1 1 0 256 90 303 and2_x1
xsubckt_125_or3_x1 1 0 353 211 212 213 or3_x1
xsubckt_35_xor2_x0 1 0 73 23 22 xor2_x0
xsubckt_251_and4_x1 1 0 125 127 132 140 49 and4_x1
xsubckt_4_inv_x0 1 0 45 300 inv_x0
xsubckt_3_inv_x0 1 0 44 301 inv_x0
xsubckt_2_inv_x0 1 0 42 302 inv_x0
xsubckt_1_inv_x0 1 0 115 303 inv_x0
xsubckt_0_inv_x0 1 0 66 304 inv_x0
xsubckt_162_nand2_x0 1 0 344 183 185 nand2_x0
xsubckt_9_inv_x0 1 0 50 295 inv_x0
xsubckt_8_inv_x0 1 0 49 296 inv_x0
xsubckt_7_inv_x0 1 0 47 297 inv_x0
xsubckt_6_inv_x0 1 0 48 298 inv_x0
xsubckt_5_inv_x0 1 0 46 299 inv_x0
xsubckt_42_xor2_x0 1 0 80 7 6 xor2_x0
xsubckt_189_and2_x1 1 0 164 65 66 and2_x1
xsubckt_150_or3_x1 1 0 347 192 193 194 or3_x1
xsubckt_68_nand3_x0 1 0 254 263 69 115 nand3_x0
xsubckt_219_nand3_x0 1 0 145 146 262 115 nand3_x0
xsubckt_158_or3_x1 1 0 345 186 187 188 or3_x1
xsubckt_118_and2_x1 1 0 216 105 303 and2_x1
xsubckt_104_nand2_x0 1 0 358 227 229 nand2_x0
xsubckt_38_xor2_x0 1 0 76 29 28 xor2_x0
xsubckt_51_nor4_x0 1 0 269 55 53 52 51 nor4_x0
xsubckt_181_and3_x1 1 0 168 262 21 115 and3_x1
xsubckt_186_nand2_x0 1 0 338 165 167 nand2_x0
xsubckt_196_nexor2_x0 1 0 161 43 333 nexor2_x0
xsubckt_215_and4_x1 1 0 148 151 156 159 64 and4_x1
xsubckt_256_and2_x1 1 0 122 123 140 and2_x1
xsubckt_88_and3_x1 1 0 239 263 74 115 and3_x1
xsubckt_57_and21nor_x0 1 0 263 265 267 41 and21nor_x0
xsubckt_185_and21nor_x0 1 0 165 32 259 166 and21nor_x0
xsubckt_201_nexor2_x0 1 0 158 39 331 nexor2_x0
xsubckt_210_nexor2_x0 1 0 152 287 327 nexor2_x0
xsubckt_138_and3_x1 1 0 201 263 16 115 and3_x1
xsubckt_96_nand2_x0 1 0 360 233 236 nand2_x0
xsubckt_164_and2_x1 1 0 181 86 303 and2_x1
xsubckt_191_mux2_x1 1 0 65 163 259 335 mux2_x1
xsubckt_159_nand3_x0 1 0 185 263 27 115 nand3_x0
xsubckt_182_or3_x1 1 0 339 168 169 170 or3_x1
xsubckt_187_mux2_x1 1 0 114 33 115 337 mux2_x1
xsubckt_231_nexor2_x0 1 0 139 284 320 nexor2_x0
xsubckt_95_nor2_x0 1 0 233 234 235 nor2_x0
xsubckt_199_nexor2_x0 1 0 160 278 332 nexor2_x0
xsubckt_244_and3_x1 1 0 129 130 132 140 and3_x1
xsubckt_145_nor2_x0 1 0 195 196 197 nor2_x0
xsubckt_10_inv_x0 1 0 51 294 inv_x0
xsubckt_11_inv_x0 1 0 52 293 inv_x0
xsubckt_12_inv_x0 1 0 53 292 inv_x0
xsubckt_13_inv_x0 1 0 55 291 inv_x0
xsubckt_14_inv_x0 1 0 56 290 inv_x0
xsubckt_142_nand3_x0 1 0 198 262 30 115 nand3_x0
xsubckt_113_and3_x1 1 0 220 263 80 115 and3_x1
xsubckt_15_inv_x0 1 0 57 289 inv_x0
xsubckt_16_inv_x0 1 0 64 288 inv_x0
xsubckt_17_inv_x0 1 0 35 287 inv_x0
xsubckt_18_inv_x0 1 0 61 286 inv_x0
xsubckt_19_inv_x0 1 0 59 285 inv_x0
xsubckt_75_or3_x1 1 0 365 249 250 251 or3_x1
xsubckt_212_and3_x1 1 0 150 151 156 159 and3_x1
xsubckt_252_nexor2_x0 1 0 126 296 312 nexor2_x0
xsubckt_103_and21nor_x0 1 0 227 19 259 228 and21nor_x0
xsubckt_85_and2_x1 1 0 241 96 303 and2_x1
xsubckt_234_nexor2_x0 1 0 138 289 319 nexor2_x0
xsubckt_135_and2_x1 1 0 203 109 303 and2_x1
xsubckt_66_and3_x1 1 0 255 262 9 115 and3_x1
xsubckt_170_nand2_x0 1 0 342 177 179 nand2_x0
xsubckt_225_nexor2_x0 1 0 143 286 323 nexor2_x0
xsubckt_155_and3_x1 1 0 188 263 25 115 and3_x1
xsubckt_129_nand2_x0 1 0 352 208 210 nand2_x0
xsubckt_120_nor2_x0 1 0 214 215 216 nor2_x0
xsubckt_47_or21nand_x0 1 0 273 66 65 54 or21nand_x0
xsubckt_54_nand4_x0 1 0 266 269 271 272 275 nand4_x0
xsubckt_207_nexor2_x0 1 0 154 280 329 nexor2_x0
xsubckt_208_nor2_x0 1 0 152 153 281 nor2_x0
xsubckt_264_nexor2_x0 1 0 119 301 307 nexor2_x0
xsubckt_136_and21nor_x0 1 0 202 28 259 203 and21nor_x0
xsubckt_58_or21nand_x0 1 0 262 264 266 276 or21nand_x0
xsubckt_190_xor2_x0 1 0 65 66 163 xor2_x0
xsubckt_300_dff_x1 1 0 34 116 115 dff_x1
xsubckt_301_dff_x1 1 0 336 116 66 dff_x1
xsubckt_302_dff_x1 1 0 335 116 65 dff_x1
xsubckt_303_dff_x1 1 0 334 116 54 dff_x1
xsubckt_112_nand2_x0 1 0 356 221 223 nand2_x0
xsubckt_60_and2_x1 1 0 260 89 303 and2_x1
xsubckt_76_nand3_x0 1 0 248 263 71 115 nand3_x0
xsubckt_78_and21nor_x0 1 0 246 13 259 247 and21nor_x0
xsubckt_304_dff_x1 1 0 333 116 43 dff_x1
xsubckt_305_dff_x1 1 0 332 116 40 dff_x1
xsubckt_306_dff_x1 1 0 331 116 39 dff_x1
xsubckt_307_dff_x1 1 0 330 116 38 dff_x1
xsubckt_308_dff_x1 1 0 329 116 37 dff_x1
xsubckt_309_dff_x1 1 0 328 116 36 dff_x1
xsubckt_110_and2_x1 1 0 222 103 303 and2_x1
xsubckt_30_xor2_x0 1 0 68 12 11 xor2_x0
xsubckt_80_and3_x1 1 0 245 262 14 115 and3_x1
xsubckt_222_and3_x1 1 0 143 144 262 115 and3_x1
xsubckt_330_dff_x1 1 0 307 116 44 dff_x1
xsubckt_119_and3_x1 1 0 215 263 81 115 and3_x1
xsubckt_70_and21nor_x0 1 0 252 11 259 253 and21nor_x0
xsubckt_184_and2_x1 1 0 166 113 303 and2_x1
xsubckt_197_and3_x1 1 0 159 54 40 43 and3_x1
xsubckt_257_and3_x1 1 0 121 123 140 47 and3_x1
xsubckt_268_dff_x1 1 0 368 116 67 dff_x1
xsubckt_269_dff_x1 1 0 367 116 68 dff_x1
xsubckt_332_dff_x1 1 0 305 116 41 dff_x1
xsubckt_331_dff_x1 1 0 306 116 42 dff_x1
xsubckt_130_and3_x1 1 0 207 263 12 115 and3_x1
xsubckt_106_and2_x1 1 0 225 101 303 and2_x1
xsubckt_100_or3_x1 1 0 359 230 231 232 or3_x1
xsubckt_169_and21nor_x0 1 0 177 6 259 178 and21nor_x0
xsubckt_206_nand4_x0 1 0 153 155 262 37 115 nand4_x0
xsubckt_258_nexor2_x0 1 0 122 297 310 nexor2_x0
xsubckt_152_and2_x1 1 0 190 83 303 and2_x1
xsubckt_33_xor2_x0 1 0 71 18 17 xor2_x0
xsubckt_161_and21nor_x0 1 0 183 4 259 184 and21nor_x0
xsubckt_165_and3_x1 1 0 180 262 5 115 and3_x1
xsubckt_167_nand3_x0 1 0 179 263 31 115 nand3_x0
xsubckt_198_nand4_x0 1 0 158 159 164 262 115 nand4_x0
xsubckt_290_dff_x1 1 0 346 116 23 dff_x1
xsubckt_291_dff_x1 1 0 345 116 25 dff_x1
xsubckt_292_dff_x1 1 0 344 116 27 dff_x1
xsubckt_293_dff_x1 1 0 343 116 29 dff_x1
xsubckt_108_or3_x1 1 0 357 224 225 226 or3_x1
xsubckt_98_and2_x1 1 0 231 99 303 and2_x1
xsubckt_265_nand4_x0 1 0 117 120 45 44 42 nand4_x0
xsubckt_294_dff_x1 1 0 342 116 31 dff_x1
xsubckt_295_dff_x1 1 0 341 116 3 dff_x1
xsubckt_296_dff_x1 1 0 340 116 5 dff_x1
xsubckt_297_dff_x1 1 0 339 116 7 dff_x1
xsubckt_298_dff_x1 1 0 338 116 21 dff_x1
xsubckt_148_and2_x1 1 0 193 112 303 and2_x1
xsubckt_40_xor2_x0 1 0 78 3 2 xor2_x0
xsubckt_29_xor2_x0 1 0 67 9 8 xor2_x0
xsubckt_232_and3_x1 1 0 137 58 59 57 and3_x1
xsubckt_299_dff_x1 1 0 337 116 33 dff_x1
xsubckt_133_or3_x1 1 0 351 205 206 207 or3_x1
xsubckt_109_nand3_x0 1 0 223 263 79 115 nand3_x0
xsubckt_90_and3_x1 1 0 237 262 16 115 and3_x1
xsubckt_140_and3_x1 1 0 199 262 29 115 and3_x1
xsubckt_36_xor2_x0 1 0 74 25 24 xor2_x0
xsubckt_194_nexor2_x0 1 0 162 277 334 nexor2_x0
xsubckt_254_and2_x1 1 0 124 49 48 and2_x1
xsubckt_137_nand2_x0 1 0 350 202 204 nand2_x0
xsubckt_56_nand4_x0 1 0 264 268 270 273 274 nand4_x0
xsubckt_73_and2_x1 1 0 250 93 303 and2_x1
xsubckt_123_and2_x1 1 0 212 106 303 and2_x1
xsubckt_43_xor2_x0 1 0 81 21 10 xor2_x0
xsubckt_45_nor4_x0 1 0 275 61 60 63 62 nor4_x0
xsubckt_200_nor2_x0 1 0 157 158 282 nor2_x0
xsubckt_235_and3_x1 1 0 135 137 140 56 and3_x1
xsubckt_261_and2_x1 1 0 119 120 45 and2_x1
xsubckt_84_nand3_x0 1 0 242 263 73 115 nand3_x0
xsubckt_39_xor2_x0 1 0 77 31 30 xor2_x0
xsubckt_69_and2_x1 1 0 253 92 303 and2_x1
xsubckt_166_or3_x1 1 0 343 180 181 182 or3_x1
xsubckt_241_nand3_x0 1 0 131 132 140 53 nand3_x0
xsubckt_255_and4_x1 1 0 123 124 127 133 56 and4_x1
xcmpt_one_0 1 0 34 one_x1
xsubckt_151_nand3_x0 1 0 191 263 23 115 nand3_x0
xsubckt_52_nor4_x0 1 0 268 35 64 57 56 nor4_x0
xsubckt_218_and2_x1 1 0 146 148 63 and2_x1
xsubckt_220_nexor2_x0 1 0 145 62 324 nexor2_x0
xsubckt_48_nor4_x0 1 0 272 40 43 37 36 nor4_x0
xsubckt_188_nexor2_x0 1 0 259 304 336 nexor2_x0
xsubckt_223_and4_x1 1 0 142 148 61 63 62 and4_x1
xsubckt_172_and2_x1 1 0 175 88 303 and2_x1
xsubckt_175_nand3_x0 1 0 173 263 5 115 nand3_x0
xsubckt_107_and3_x1 1 0 224 262 20 115 and3_x1
xsubckt_21_inv_x0 1 0 38 283 inv_x0
xsubckt_20_inv_x0 1 0 58 284 inv_x0
xsubckt_64_and3_x1 1 0 257 263 68 115 and3_x1
xsubckt_214_nexor2_x0 1 0 149 288 326 nexor2_x0
xsubckt_26_inv_x0 1 0 40 278 inv_x0
xsubckt_25_inv_x0 1 0 43 279 inv_x0
xsubckt_24_inv_x0 1 0 37 280 inv_x0
xsubckt_23_inv_x0 1 0 36 281 inv_x0
xsubckt_22_inv_x0 1 0 39 282 inv_x0
xsubckt_168_and2_x1 1 0 178 87 303 and2_x1
xsubckt_192_and3_x1 1 0 162 164 262 115 and3_x1
xsubckt_205_nexor2_x0 1 0 157 283 330 nexor2_x0
xsubckt_226_and4_x1 1 0 140 142 262 60 115 and4_x1
xsubckt_228_and2_x1 1 0 139 140 59 and2_x1
xsubckt_253_nexor2_x0 1 0 125 298 311 nexor2_x0
xsubckt_262_nexor2_x0 1 0 120 300 308 nexor2_x0
xsubckt_267_and2_x1 1 0 305 117 41 and2_x1
xsubckt_121_nand2_x0 1 0 354 214 217 nand2_x0
xsubckt_99_and3_x1 1 0 230 263 76 115 and3_x1
xsubckt_83_or3_x1 1 0 363 243 244 245 or3_x1
xsubckt_28_inv_x0 1 0 41 276 inv_x0
xsubckt_27_inv_x0 1 0 54 277 inv_x0
xsubckt_213_and3_x1 1 0 149 150 262 115 and3_x1
xsubckt_149_and3_x1 1 0 192 263 20 115 and3_x1
xsubckt_117_nand3_x0 1 0 217 262 24 115 nand3_x0
xsubckt_233_and4_x1 1 0 136 140 58 59 57 and4_x1
xsubckt_245_and21nor_x0 1 0 315 293 131 129 and21nor_x0
xsubckt_93_and2_x1 1 0 235 98 303 and2_x1
xsubckt_217_nexor2_x0 1 0 147 63 325 nexor2_x0
xsubckt_143_and2_x1 1 0 197 111 303 and2_x1
xsubckt_310_dff_x1 1 0 327 116 35 dff_x1
xsubckt_111_and21nor_x0 1 0 221 22 259 222 and21nor_x0
xsubckt_89_and2_x1 1 0 238 97 303 and2_x1
xsubckt_61_and2_x1 1 0 259 262 115 and2_x1
xsubckt_74_and3_x1 1 0 249 262 12 115 and3_x1
xsubckt_195_nor2_x0 1 0 160 161 279 nor2_x0
xsubckt_203_and2_x1 1 0 155 156 159 and2_x1
xsubckt_247_nexor2_x0 1 0 129 294 314 nexor2_x0
xsubckt_311_dff_x1 1 0 326 116 64 dff_x1
xsubckt_312_dff_x1 1 0 325 116 63 dff_x1
xsubckt_313_dff_x1 1 0 324 116 62 dff_x1
xsubckt_314_dff_x1 1 0 323 116 61 dff_x1
xsubckt_315_dff_x1 1 0 322 116 60 dff_x1
xsubckt_316_dff_x1 1 0 321 116 59 dff_x1
xsubckt_139_and2_x1 1 0 200 110 303 and2_x1
xsubckt_124_and3_x1 1 0 211 262 25 115 and3_x1
xsubckt_92_nand3_x0 1 0 236 262 17 115 nand3_x0
xsubckt_31_xor2_x0 1 0 69 14 13 xor2_x0
xsubckt_163_and3_x1 1 0 182 263 29 115 and3_x1
xsubckt_229_nexor2_x0 1 0 140 285 321 nexor2_x0
xsubckt_238_nexor2_x0 1 0 135 291 317 nexor2_x0
xsubckt_270_dff_x1 1 0 366 116 69 dff_x1
xsubckt_271_dff_x1 1 0 365 116 70 dff_x1
xsubckt_272_dff_x1 1 0 364 116 71 dff_x1
xsubckt_273_dff_x1 1 0 363 116 72 dff_x1
xsubckt_317_dff_x1 1 0 320 116 58 dff_x1
xsubckt_318_dff_x1 1 0 319 116 57 dff_x1
xsubckt_319_dff_x1 1 0 318 116 56 dff_x1
xsubckt_55_and4_x1 1 0 265 268 270 273 274 and4_x1
xsubckt_274_dff_x1 1 0 362 116 73 dff_x1
xsubckt_275_dff_x1 1 0 361 116 74 dff_x1
xsubckt_276_dff_x1 1 0 360 116 75 dff_x1
xsubckt_277_dff_x1 1 0 359 116 76 dff_x1
xsubckt_278_dff_x1 1 0 358 116 77 dff_x1
xsubckt_279_dff_x1 1 0 357 116 78 dff_x1
xsubckt_230_and3_x1 1 0 138 140 58 59 and3_x1
xsubckt_86_and21nor_x0 1 0 240 15 259 241 and21nor_x0
xsubckt_79_nand2_x0 1 0 364 246 248 nand2_x0
xsubckt_239_and4_x1 1 0 133 58 59 57 55 and4_x1
xsubckt_146_nand2_x0 1 0 348 195 198 nand2_x0
xsubckt_116_or3_x1 1 0 355 218 219 220 or3_x1
xsubckt_114_and2_x1 1 0 219 104 303 and2_x1
xsubckt_101_nand3_x0 1 0 229 263 77 115 nand3_x0
xsubckt_34_xor2_x0 1 0 72 20 19 xor2_x0
xsubckt_183_nand3_x0 1 0 167 263 21 115 nand3_x0
xsubckt_173_and3_x1 1 0 174 262 7 115 and3_x1
xsubckt_177_and21nor_x0 1 0 171 10 259 172 and21nor_x0
xsubckt_246_and4_x1 1 0 128 130 132 140 51 and4_x1
xsubckt_160_and2_x1 1 0 184 85 303 and2_x1
xsubckt_141_or3_x1 1 0 349 199 200 201 or3_x1
xsubckt_41_xor2_x0 1 0 79 5 4 xor2_x0
xsubckt_156_and2_x1 1 0 187 84 303 and2_x1
xsubckt_37_xor2_x0 1 0 75 27 26 xor2_x0
xsubckt_50_nor4_x0 1 0 270 46 45 44 42 nor4_x0
xsubckt_44_xor2_x0 1 0 82 33 32 xor2_x0
xsubckt_46_nor4_x0 1 0 274 39 38 58 59 nor4_x0
xsubckt_249_and4_x1 1 0 127 53 52 51 50 and4_x1
.ends expmob2
