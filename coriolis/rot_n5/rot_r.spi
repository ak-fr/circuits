* Coriolis Structural SPICE Driver
* Generated on Apr 13, 2025, 21:57
* Cell/Subckt "rot_r".
*
* INTERF vss
* INTERF vdd
* INTERF rotated_bits[9]
* INTERF rotated_bits[8]
* INTERF rotated_bits[7]
* INTERF rotated_bits[6]
* INTERF rotated_bits[5]
* INTERF rotated_bits[4]
* INTERF rotated_bits[31]
* INTERF rotated_bits[30]
* INTERF rotated_bits[3]
* INTERF rotated_bits[29]
* INTERF rotated_bits[28]
* INTERF rotated_bits[27]
* INTERF rotated_bits[26]
* INTERF rotated_bits[25]
* INTERF rotated_bits[24]
* INTERF rotated_bits[23]
* INTERF rotated_bits[22]
* INTERF rotated_bits[21]
* INTERF rotated_bits[20]
* INTERF rotated_bits[2]
* INTERF rotated_bits[19]
* INTERF rotated_bits[18]
* INTERF rotated_bits[17]
* INTERF rotated_bits[16]
* INTERF rotated_bits[15]
* INTERF rotated_bits[14]
* INTERF rotated_bits[13]
* INTERF rotated_bits[12]
* INTERF rotated_bits[11]
* INTERF rotated_bits[10]
* INTERF rotated_bits[1]
* INTERF rotated_bits[0]
* INTERF k[4]
* INTERF k[3]
* INTERF k[2]
* INTERF k[1]
* INTERF k[0]
* INTERF bits[9]
* INTERF bits[8]
* INTERF bits[7]
* INTERF bits[6]
* INTERF bits[5]
* INTERF bits[4]
* INTERF bits[31]
* INTERF bits[30]
* INTERF bits[3]
* INTERF bits[29]
* INTERF bits[28]
* INTERF bits[27]
* INTERF bits[26]
* INTERF bits[25]
* INTERF bits[24]
* INTERF bits[23]
* INTERF bits[22]
* INTERF bits[21]
* INTERF bits[20]
* INTERF bits[2]
* INTERF bits[19]
* INTERF bits[18]
* INTERF bits[17]
* INTERF bits[16]
* INTERF bits[15]
* INTERF bits[14]
* INTERF bits[13]
* INTERF bits[12]
* INTERF bits[11]
* INTERF bits[10]
* INTERF bits[1]
* INTERF bits[0]

* Terminal models (aka standard cells) used througout all the hierarchy.
.include mux2_x1.spi
.include tie.spi
.include decap_w0.spi
.include inv_x0.spi

* Non-terminal models (part of the user's design hierarchy).

.subckt rot_r 0 1 2 3 4 5 6 7 8 9 10 11 12 13 14 15 16 17 18 19 20 21 22 23 24 25 26 27 28 29 30 31 32 33 34 35 36 37 38 40 41 42 43 44 45 46 47 48 49 50 51 52 53 54 55 56 57 58 59 60 61 62 63 64 65 66 67 68 69 70 71
* NET     0 = vss
* NET     1 = vdd
* NET     2 = rotated_bits[9]
* NET     3 = rotated_bits[8]
* NET     4 = rotated_bits[7]
* NET     5 = rotated_bits[6]
* NET     6 = rotated_bits[5]
* NET     7 = rotated_bits[4]
* NET     8 = rotated_bits[31]
* NET     9 = rotated_bits[30]
* NET    10 = rotated_bits[3]
* NET    11 = rotated_bits[29]
* NET    12 = rotated_bits[28]
* NET    13 = rotated_bits[27]
* NET    14 = rotated_bits[26]
* NET    15 = rotated_bits[25]
* NET    16 = rotated_bits[24]
* NET    17 = rotated_bits[23]
* NET    18 = rotated_bits[22]
* NET    19 = rotated_bits[21]
* NET    20 = rotated_bits[20]
* NET    21 = rotated_bits[2]
* NET    22 = rotated_bits[19]
* NET    23 = rotated_bits[18]
* NET    24 = rotated_bits[17]
* NET    25 = rotated_bits[16]
* NET    26 = rotated_bits[15]
* NET    27 = rotated_bits[14]
* NET    28 = rotated_bits[13]
* NET    29 = rotated_bits[12]
* NET    30 = rotated_bits[11]
* NET    31 = rotated_bits[10]
* NET    32 = rotated_bits[1]
* NET    33 = rotated_bits[0]
* NET    34 = k[4]
* NET    35 = k[3]
* NET    36 = k[2]
* NET    37 = k[1]
* NET    38 = k[0]
* NET    39 = blockagenet
* NET    40 = bits[9]
* NET    41 = bits[8]
* NET    42 = bits[7]
* NET    43 = bits[6]
* NET    44 = bits[5]
* NET    45 = bits[4]
* NET    46 = bits[31]
* NET    47 = bits[30]
* NET    48 = bits[3]
* NET    49 = bits[29]
* NET    50 = bits[28]
* NET    51 = bits[27]
* NET    52 = bits[26]
* NET    53 = bits[25]
* NET    54 = bits[24]
* NET    55 = bits[23]
* NET    56 = bits[22]
* NET    57 = bits[21]
* NET    58 = bits[20]
* NET    59 = bits[2]
* NET    60 = bits[19]
* NET    61 = bits[18]
* NET    62 = bits[17]
* NET    63 = bits[16]
* NET    64 = bits[15]
* NET    65 = bits[14]
* NET    66 = bits[13]
* NET    67 = bits[12]
* NET    68 = bits[11]
* NET    69 = bits[10]
* NET    70 = bits[1]
* NET    71 = bits[0]
* NET    72 = abc_611_new_n99
* NET    73 = abc_611_new_n98
* NET    74 = abc_611_new_n97
* NET    75 = abc_611_new_n96
* NET    76 = abc_611_new_n95
* NET    77 = abc_611_new_n94
* NET    78 = abc_611_new_n93
* NET    79 = abc_611_new_n92
* NET    80 = abc_611_new_n91
* NET    81 = abc_611_new_n90
* NET    82 = abc_611_new_n89
* NET    83 = abc_611_new_n88
* NET    84 = abc_611_new_n87
* NET    85 = abc_611_new_n86
* NET    86 = abc_611_new_n85
* NET    87 = abc_611_new_n84
* NET    88 = abc_611_new_n83
* NET    89 = abc_611_new_n82
* NET    90 = abc_611_new_n81
* NET    91 = abc_611_new_n80
* NET    92 = abc_611_new_n79
* NET    93 = abc_611_new_n78
* NET    94 = abc_611_new_n77
* NET    95 = abc_611_new_n76
* NET    96 = abc_611_new_n75
* NET    97 = abc_611_new_n74
* NET    98 = abc_611_new_n73
* NET    99 = abc_611_new_n72
* NET   100 = abc_611_new_n71
* NET   101 = abc_611_new_n70
* NET   102 = abc_611_new_n231
* NET   103 = abc_611_new_n229
* NET   104 = abc_611_new_n227
* NET   105 = abc_611_new_n226
* NET   106 = abc_611_new_n224
* NET   107 = abc_611_new_n223
* NET   108 = abc_611_new_n221
* NET   109 = abc_611_new_n220
* NET   110 = abc_611_new_n218
* NET   111 = abc_611_new_n217
* NET   112 = abc_611_new_n215
* NET   113 = abc_611_new_n214
* NET   114 = abc_611_new_n213
* NET   115 = abc_611_new_n211
* NET   116 = abc_611_new_n210
* NET   117 = abc_611_new_n209
* NET   118 = abc_611_new_n207
* NET   119 = abc_611_new_n206
* NET   120 = abc_611_new_n205
* NET   121 = abc_611_new_n203
* NET   122 = abc_611_new_n202
* NET   123 = abc_611_new_n201
* NET   124 = abc_611_new_n199
* NET   125 = abc_611_new_n198
* NET   126 = abc_611_new_n197
* NET   127 = abc_611_new_n195
* NET   128 = abc_611_new_n194
* NET   129 = abc_611_new_n193
* NET   130 = abc_611_new_n191
* NET   131 = abc_611_new_n190
* NET   132 = abc_611_new_n189
* NET   133 = abc_611_new_n187
* NET   134 = abc_611_new_n186
* NET   135 = abc_611_new_n185
* NET   136 = abc_611_new_n183
* NET   137 = abc_611_new_n182
* NET   138 = abc_611_new_n181
* NET   139 = abc_611_new_n180
* NET   140 = abc_611_new_n178
* NET   141 = abc_611_new_n177
* NET   142 = abc_611_new_n176
* NET   143 = abc_611_new_n175
* NET   144 = abc_611_new_n173
* NET   145 = abc_611_new_n172
* NET   146 = abc_611_new_n171
* NET   147 = abc_611_new_n170
* NET   148 = abc_611_new_n168
* NET   149 = abc_611_new_n167
* NET   150 = abc_611_new_n166
* NET   151 = abc_611_new_n165
* NET   152 = abc_611_new_n163
* NET   153 = abc_611_new_n162
* NET   154 = abc_611_new_n161
* NET   155 = abc_611_new_n160
* NET   156 = abc_611_new_n158
* NET   157 = abc_611_new_n157
* NET   158 = abc_611_new_n156
* NET   159 = abc_611_new_n155
* NET   160 = abc_611_new_n153
* NET   161 = abc_611_new_n152
* NET   162 = abc_611_new_n151
* NET   163 = abc_611_new_n150
* NET   164 = abc_611_new_n148
* NET   165 = abc_611_new_n147
* NET   166 = abc_611_new_n146
* NET   167 = abc_611_new_n145
* NET   168 = abc_611_new_n143
* NET   169 = abc_611_new_n142
* NET   170 = abc_611_new_n141
* NET   171 = abc_611_new_n140
* NET   172 = abc_611_new_n138
* NET   173 = abc_611_new_n137
* NET   174 = abc_611_new_n136
* NET   175 = abc_611_new_n135
* NET   176 = abc_611_new_n133
* NET   177 = abc_611_new_n132
* NET   178 = abc_611_new_n131
* NET   179 = abc_611_new_n130
* NET   180 = abc_611_new_n128
* NET   181 = abc_611_new_n127
* NET   182 = abc_611_new_n126
* NET   183 = abc_611_new_n125
* NET   184 = abc_611_new_n123
* NET   185 = abc_611_new_n122
* NET   186 = abc_611_new_n121
* NET   187 = abc_611_new_n120
* NET   188 = abc_611_new_n118
* NET   189 = abc_611_new_n117
* NET   190 = abc_611_new_n116
* NET   191 = abc_611_new_n115
* NET   192 = abc_611_new_n113
* NET   193 = abc_611_new_n112
* NET   194 = abc_611_new_n111
* NET   195 = abc_611_new_n110
* NET   196 = abc_611_new_n108
* NET   197 = abc_611_new_n107
* NET   198 = abc_611_new_n106
* NET   199 = abc_611_new_n105
* NET   200 = abc_611_new_n103
* NET   201 = abc_611_new_n102
* NET   202 = abc_611_new_n101
* NET   203 = abc_611_new_n100

xsubckt_58_mux2_x1 1 0 181 189 35 180 mux2_x1
xsubckt_44_mux2_x1 1 0 192 196 34 21 mux2_x1
xsubckt_19_mux2_x1 1 0 46 64 38 82 mux2_x1
xsubckt_5_mux2_x1 1 0 54 41 38 96 mux2_x1
xsubckt_83_mux2_x1 1 0 161 169 35 160 mux2_x1
xsubckt_97_mux2_x1 1 0 150 166 36 149 mux2_x1
xsubckt_112_mux2_x1 1 0 138 154 36 137 mux2_x1
xsubckt_30_mux2_x1 1 0 62 70 38 203 mux2_x1
xsubckt_108_mux2_x1 1 0 141 149 35 140 mux2_x1
xsubckt_133_mux2_x1 1 0 122 128 35 121 mux2_x1
xsubckt_147_mux2_x1 1 0 123 202 100 111 mux2_x1
xsubckt_79_mux2_x1 1 0 164 168 34 2 mux2_x1
xsubckt_65_mux2_x1 1 0 42 55 38 175 mux2_x1
xsubckt_51_mux2_x1 1 0 187 94 37 186 mux2_x1
xsubckt_26_mux2_x1 1 0 49 66 38 75 mux2_x1
xsubckt_90_mux2_x1 1 0 67 50 38 155 mux2_x1
xsubckt_12_mux2_x1 1 0 56 43 38 89 mux2_x1
xsubckt_115_mux2_x1 1 0 167 203 101 135 mux2_x1
xsubckt_129_mux2_x1 1 0 125 131 35 124 mux2_x1
xsubckt_140_mux2_x1 1 0 117 129 36 116 mux2_x1
xsubckt_154_mux2_x1 1 0 107 111 35 106 mux2_x1
xsubckt_72_mux2_x1 1 0 170 186 36 169 mux2_x1
xsubckt_47_mux2_x1 1 0 190 80 36 189 mux2_x1
xsubckt_8_mux2_x1 1 0 58 45 38 93 mux2_x1
xsubckt_33_mux2_x1 1 0 201 76 99 200 mux2_x1
xsubckt_86_mux2_x1 1 0 159 191 37 158 mux2_x1
xsubckt_101_mux2_x1 1 0 147 179 37 146 mux2_x1
xsubckt_161_mux2_x1 1 0 105 84 99 102 mux2_x1
xsubckt_122_mux2_x1 1 0 130 133 34 23 mux2_x1
xsubckt_136_mux2_x1 1 0 120 132 36 119 mux2_x1
xsubckt_68_mux2_x1 1 0 173 181 35 172 mux2_x1
xsubckt_54_mux2_x1 1 0 184 188 34 7 mux2_x1
xsubckt_15_mux2_x1 1 0 61 59 38 86 mux2_x1
xsubckt_29_mux2_x1 1 0 53 40 38 72 mux2_x1
xsubckt_40_mux2_x1 1 0 59 61 38 195 mux2_x1
xsubckt_93_mux2_x1 1 0 153 161 35 152 mux2_x1
xsubckt_157_mux2_x1 1 0 105 109 35 104 mux2_x1
xsubckt_89_mux2_x1 1 0 156 160 34 30 mux2_x1
xsubckt_104_mux2_x1 1 0 144 148 34 27 mux2_x1
xsubckt_118_mux2_x1 1 0 133 136 34 24 mux2_x1
xsubckt_143_mux2_x1 1 0 139 96 101 114 mux2_x1
xsubckt_75_mux2_x1 1 0 40 53 38 167 mux2_x1
xsubckt_61_mux2_x1 1 0 179 90 37 178 mux2_x1
xsubckt_22_mux2_x1 1 0 51 68 38 79 mux2_x1
xsubckt_36_mux2_x1 1 0 199 72 37 198 mux2_x1
xsubckt_139_mux2_x1 1 0 143 81 101 117 mux2_x1
xsubckt_4_mux2_x1 1 0 71 63 38 97 mux2_x1
xsubckt_96_mux2_x1 1 0 151 183 37 150 mux2_x1
xsubckt_111_mux2_x1 1 0 139 171 37 138 mux2_x1
xsubckt_125_mux2_x1 1 0 128 134 35 127 mux2_x1
xsubckt_150_mux2_x1 1 0 120 85 100 109 mux2_x1
xsubckt_57_mux2_x1 1 0 182 198 36 181 mux2_x1
xsubckt_43_mux2_x1 1 0 193 91 35 192 mux2_x1
xsubckt_18_mux2_x1 1 0 84 91 99 83 mux2_x1
xsubckt_82_mux2_x1 1 0 162 178 36 161 mux2_x1
xsubckt_146_mux2_x1 1 0 112 115 34 16 mux2_x1
xsubckt_78_mux2_x1 1 0 165 173 35 164 mux2_x1
xsubckt_39_mux2_x1 1 0 196 83 34 32 mux2_x1
xsubckt_107_mux2_x1 1 0 142 158 36 141 mux2_x1
xsubckt_132_mux2_x1 1 0 123 135 36 122 mux2_x1
xsubckt_64_mux2_x1 1 0 176 180 34 5 mux2_x1
xsubckt_50_mux2_x1 1 0 45 58 38 187 mux2_x1
xsubckt_11_mux2_x1 1 0 47 65 38 90 mux2_x1
xsubckt_25_mux2_x1 1 0 77 80 100 76 mux2_x1
xsubckt_128_mux2_x1 1 0 126 138 36 125 mux2_x1
xsubckt_153_mux2_x1 1 0 117 77 100 107 mux2_x1
xsubckt_46_mux2_x1 1 0 191 79 37 190 mux2_x1
xsubckt_7_mux2_x1 1 0 50 67 38 94 mux2_x1
xsubckt_85_mux2_x1 1 0 68 51 38 159 mux2_x1
xsubckt_99_mux2_x1 1 0 148 152 34 28 mux2_x1
xsubckt_100_mux2_x1 1 0 65 47 38 147 mux2_x1
xsubckt_114_mux2_x1 1 0 136 140 34 25 mux2_x1
xsubckt_71_mux2_x1 1 0 171 97 37 170 mux2_x1
xsubckt_32_mux2_x1 1 0 202 73 100 201 mux2_x1
xsubckt_135_mux2_x1 1 0 147 89 101 120 mux2_x1
xsubckt_149_mux2_x1 1 0 110 112 34 15 mux2_x1
xsubckt_160_mux2_x1 1 0 103 104 34 11 mux2_x1
xsubckt_67_mux2_x1 1 0 174 190 36 173 mux2_x1
xsubckt_53_mux2_x1 1 0 185 193 35 184 mux2_x1
xsubckt_28_mux2_x1 1 0 74 75 101 73 mux2_x1
xsubckt_92_mux2_x1 1 0 154 170 36 153 mux2_x1
xsubckt_121_mux2_x1 1 0 131 137 35 130 mux2_x1
xfeed_0 1 0 tie
xsubckt_14_mux2_x1 1 0 52 69 38 87 mux2_x1
xsubckt_117_mux2_x1 1 0 134 141 35 133 mux2_x1
xsubckt_142_mux2_x1 1 0 115 118 34 17 mux2_x1
xsubckt_156_mux2_x1 1 0 114 92 100 105 mux2_x1
xfeed_9 1 0 decap_w0
xfeed_8 1 0 tie
xfeed_7 1 0 tie
xfeed_6 1 0 decap_w0
xfeed_5 1 0 tie
xfeed_4 1 0 decap_w0
xfeed_3 1 0 tie
xfeed_2 1 0 decap_w0
xfeed_1 1 0 decap_w0
xsubckt_74_mux2_x1 1 0 168 172 34 3 mux2_x1
xsubckt_60_mux2_x1 1 0 43 56 38 179 mux2_x1
xsubckt_49_mux2_x1 1 0 188 192 34 10 mux2_x1
xsubckt_0_inv_x0 1 0 37 101 inv_x0
xsubckt_1_inv_x0 1 0 36 100 inv_x0
xsubckt_2_inv_x0 1 0 35 99 inv_x0
xsubckt_3_inv_x0 1 0 34 98 inv_x0
xsubckt_35_mux2_x1 1 0 70 62 38 199 mux2_x1
xsubckt_88_mux2_x1 1 0 157 165 35 156 mux2_x1
xsubckt_103_mux2_x1 1 0 145 153 35 144 mux2_x1
xsubckt_163_mux2_x1 1 0 102 200 98 8 mux2_x1
xsubckt_21_mux2_x1 1 0 81 82 101 80 mux2_x1
xsubckt_124_mux2_x1 1 0 129 142 36 128 mux2_x1
xsubckt_138_mux2_x1 1 0 118 121 34 18 mux2_x1
xfeed_19 1 0 decap_w0
xfeed_18 1 0 decap_w0
xfeed_17 1 0 decap_w0
xfeed_16 1 0 tie
xfeed_15 1 0 tie
xfeed_14 1 0 decap_w0
xfeed_13 1 0 tie
xfeed_12 1 0 decap_w0
xfeed_11 1 0 decap_w0
xfeed_10 1 0 decap_w0
xsubckt_56_mux2_x1 1 0 183 75 37 182 mux2_x1
xsubckt_42_mux2_x1 1 0 194 88 36 193 mux2_x1
xsubckt_17_mux2_x1 1 0 85 88 100 84 mux2_x1
xsubckt_81_mux2_x1 1 0 163 195 37 162 mux2_x1
xsubckt_95_mux2_x1 1 0 66 49 38 151 mux2_x1
xsubckt_110_mux2_x1 1 0 63 71 38 139 mux2_x1
xsubckt_106_mux2_x1 1 0 143 175 37 142 mux2_x1
xsubckt_131_mux2_x1 1 0 151 74 101 123 mux2_x1
xsubckt_145_mux2_x1 1 0 113 119 35 112 mux2_x1
xsubckt_159_mux2_x1 1 0 107 201 99 103 mux2_x1
xfeed_29 1 0 decap_w0
xfeed_28 1 0 decap_w0
xfeed_27 1 0 decap_w0
xfeed_26 1 0 decap_w0
xfeed_25 1 0 decap_w0
xfeed_24 1 0 decap_w0
xfeed_23 1 0 decap_w0
xfeed_22 1 0 tie
xfeed_21 1 0 decap_w0
xfeed_20 1 0 decap_w0
xsubckt_77_mux2_x1 1 0 166 182 36 165 mux2_x1
xsubckt_63_mux2_x1 1 0 177 185 35 176 mux2_x1
xsubckt_24_mux2_x1 1 0 78 79 101 77 mux2_x1
xsubckt_38_mux2_x1 1 0 197 76 35 196 mux2_x1
xspare_feed_13 1 0 decap_w0
xspare_feed_12 1 0 tie
xspare_feed_11 1 0 tie
xspare_feed_10 1 0 decap_w0
xsubckt_6_mux2_x1 1 0 96 97 101 95 mux2_x1
xsubckt_10_mux2_x1 1 0 92 95 100 91 mux2_x1
xsubckt_98_mux2_x1 1 0 149 157 35 148 mux2_x1
xsubckt_113_mux2_x1 1 0 137 145 35 136 mux2_x1
xsubckt_127_mux2_x1 1 0 155 93 101 126 mux2_x1
xsubckt_152_mux2_x1 1 0 108 110 34 14 mux2_x1
xfeed_39 1 0 decap_w0
xfeed_38 1 0 decap_w0
xfeed_37 1 0 decap_w0
xfeed_36 1 0 decap_w0
xfeed_35 1 0 decap_w0
xfeed_34 1 0 decap_w0
xfeed_33 1 0 decap_w0
xfeed_32 1 0 decap_w0
xfeed_31 1 0 tie
xfeed_30 1 0 decap_w0
xspare_feed_15 1 0 tie
xspare_feed_14 1 0 tie
xsubckt_70_mux2_x1 1 0 41 54 38 171 mux2_x1
xsubckt_59_mux2_x1 1 0 180 184 34 6 mux2_x1
xsubckt_45_mux2_x1 1 0 48 60 38 191 mux2_x1
xsubckt_31_mux2_x1 1 0 203 72 101 202 mux2_x1
xsubckt_84_mux2_x1 1 0 160 164 34 31 mux2_x1
xsubckt_148_mux2_x1 1 0 111 116 35 110 mux2_x1
xsubckt_109_mux2_x1 1 0 140 144 34 26 mux2_x1
xsubckt_120_mux2_x1 1 0 132 146 36 131 mux2_x1
xsubckt_134_mux2_x1 1 0 121 124 34 19 mux2_x1
xfeed_46 1 0 decap_w0
xfeed_45 1 0 decap_w0
xfeed_44 1 0 tie
xfeed_43 1 0 decap_w0
xfeed_42 1 0 decap_w0
xfeed_41 1 0 decap_w0
xfeed_40 1 0 decap_w0
xsubckt_66_mux2_x1 1 0 175 82 37 174 mux2_x1
xsubckt_52_mux2_x1 1 0 186 95 36 185 mux2_x1
xsubckt_13_mux2_x1 1 0 89 90 101 88 mux2_x1
xsubckt_27_mux2_x1 1 0 57 44 38 74 mux2_x1
xsubckt_91_mux2_x1 1 0 155 187 37 154 mux2_x1
xsubckt_155_mux2_x1 1 0 106 108 34 13 mux2_x1
xfeed_49 1 0 decap_w0
xfeed_48 1 0 decap_w0
xfeed_47 1 0 decap_w0
xspare_feed_9 1 0 tie
xspare_feed_8 1 0 tie
xspare_feed_7 1 0 decap_w0
xspare_feed_6 1 0 tie
xspare_feed_5 1 0 tie
xspare_feed_4 1 0 decap_w0
xspare_feed_3 1 0 tie
xspare_feed_2 1 0 tie
xspare_feed_1 1 0 tie
xspare_feed_0 1 0 tie
xsubckt_48_mux2_x1 1 0 189 197 35 188 mux2_x1
xsubckt_9_mux2_x1 1 0 93 94 101 92 mux2_x1
xsubckt_87_mux2_x1 1 0 158 174 36 157 mux2_x1
xsubckt_102_mux2_x1 1 0 146 162 36 145 mux2_x1
xsubckt_116_mux2_x1 1 0 135 150 36 134 mux2_x1
xsubckt_141_mux2_x1 1 0 116 122 35 115 mux2_x1
xfeed_53 1 0 decap_w0
xfeed_52 1 0 decap_w0
xfeed_51 1 0 decap_w0
xfeed_50 1 0 tie
xsubckt_162_mux2_x1 1 0 102 103 34 9 mux2_x1
xsubckt_73_mux2_x1 1 0 169 177 35 168 mux2_x1
xsubckt_20_mux2_x1 1 0 55 42 38 81 mux2_x1
xsubckt_34_mux2_x1 1 0 200 83 98 33 mux2_x1
xsubckt_137_mux2_x1 1 0 119 125 35 118 mux2_x1
xsubckt_69_mux2_x1 1 0 172 176 34 4 mux2_x1
xsubckt_55_mux2_x1 1 0 44 57 38 183 mux2_x1
xsubckt_94_mux2_x1 1 0 152 156 34 29 mux2_x1
xsubckt_123_mux2_x1 1 0 159 78 101 129 mux2_x1
xsubckt_80_mux2_x1 1 0 69 52 38 163 mux2_x1
xsubckt_41_mux2_x1 1 0 195 87 37 194 mux2_x1
xsubckt_16_mux2_x1 1 0 86 87 101 85 mux2_x1
xsubckt_119_mux2_x1 1 0 163 86 101 132 mux2_x1
xsubckt_144_mux2_x1 1 0 114 126 36 113 mux2_x1
xsubckt_158_mux2_x1 1 0 104 106 34 12 mux2_x1
xsubckt_76_mux2_x1 1 0 167 199 37 166 mux2_x1
xsubckt_62_mux2_x1 1 0 178 194 36 177 mux2_x1
xsubckt_37_mux2_x1 1 0 198 73 36 197 mux2_x1
xsubckt_105_mux2_x1 1 0 64 46 38 143 mux2_x1
xsubckt_130_mux2_x1 1 0 124 127 34 20 mux2_x1
xsubckt_23_mux2_x1 1 0 60 48 38 78 mux2_x1
xsubckt_126_mux2_x1 1 0 127 130 34 22 mux2_x1
xsubckt_151_mux2_x1 1 0 109 113 35 108 mux2_x1
.ends rot_r
