* Coriolis Structural SPICE Driver
* Generated on Apr 17, 2025, 14:34
* Cell/Subckt "expmob2".
*
* INTERF vss
* INTERF vdd
* INTERF outputs[99]
* INTERF outputs[98]
* INTERF outputs[97]
* INTERF outputs[96]
* INTERF outputs[95]
* INTERF outputs[94]
* INTERF outputs[93]
* INTERF outputs[92]
* INTERF outputs[91]
* INTERF outputs[90]
* INTERF outputs[9]
* INTERF outputs[89]
* INTERF outputs[88]
* INTERF outputs[87]
* INTERF outputs[86]
* INTERF outputs[85]
* INTERF outputs[84]
* INTERF outputs[83]
* INTERF outputs[82]
* INTERF outputs[81]
* INTERF outputs[80]
* INTERF outputs[8]
* INTERF outputs[79]
* INTERF outputs[78]
* INTERF outputs[77]
* INTERF outputs[76]
* INTERF outputs[75]
* INTERF outputs[74]
* INTERF outputs[73]
* INTERF outputs[72]
* INTERF outputs[71]
* INTERF outputs[70]
* INTERF outputs[7]
* INTERF outputs[69]
* INTERF outputs[68]
* INTERF outputs[67]
* INTERF outputs[66]
* INTERF outputs[65]
* INTERF outputs[64]
* INTERF outputs[63]
* INTERF outputs[62]
* INTERF outputs[61]
* INTERF outputs[60]
* INTERF outputs[6]
* INTERF outputs[59]
* INTERF outputs[58]
* INTERF outputs[57]
* INTERF outputs[56]
* INTERF outputs[55]
* INTERF outputs[54]
* INTERF outputs[53]
* INTERF outputs[52]
* INTERF outputs[51]
* INTERF outputs[50]
* INTERF outputs[5]
* INTERF outputs[49]
* INTERF outputs[48]
* INTERF outputs[47]
* INTERF outputs[46]
* INTERF outputs[45]
* INTERF outputs[44]
* INTERF outputs[43]
* INTERF outputs[42]
* INTERF outputs[41]
* INTERF outputs[40]
* INTERF outputs[4]
* INTERF outputs[39]
* INTERF outputs[38]
* INTERF outputs[37]
* INTERF outputs[36]
* INTERF outputs[35]
* INTERF outputs[34]
* INTERF outputs[33]
* INTERF outputs[32]
* INTERF outputs[31]
* INTERF outputs[30]
* INTERF outputs[3]
* INTERF outputs[29]
* INTERF outputs[28]
* INTERF outputs[27]
* INTERF outputs[26]
* INTERF outputs[25]
* INTERF outputs[24]
* INTERF outputs[23]
* INTERF outputs[22]
* INTERF outputs[21]
* INTERF outputs[20]
* INTERF outputs[2]
* INTERF outputs[19]
* INTERF outputs[18]
* INTERF outputs[17]
* INTERF outputs[16]
* INTERF outputs[15]
* INTERF outputs[14]
* INTERF outputs[13]
* INTERF outputs[127]
* INTERF outputs[126]
* INTERF outputs[125]
* INTERF outputs[124]
* INTERF outputs[123]
* INTERF outputs[122]
* INTERF outputs[121]
* INTERF outputs[120]
* INTERF outputs[12]
* INTERF outputs[119]
* INTERF outputs[118]
* INTERF outputs[117]
* INTERF outputs[116]
* INTERF outputs[115]
* INTERF outputs[114]
* INTERF outputs[113]
* INTERF outputs[112]
* INTERF outputs[111]
* INTERF outputs[110]
* INTERF outputs[11]
* INTERF outputs[109]
* INTERF outputs[108]
* INTERF outputs[107]
* INTERF outputs[106]
* INTERF outputs[105]
* INTERF outputs[104]
* INTERF outputs[103]
* INTERF outputs[102]
* INTERF outputs[101]
* INTERF outputs[100]
* INTERF outputs[10]
* INTERF outputs[1]
* INTERF outputs[0]
* INTERF inputs[99]
* INTERF inputs[98]
* INTERF inputs[97]
* INTERF inputs[96]
* INTERF inputs[95]
* INTERF inputs[94]
* INTERF inputs[93]
* INTERF inputs[92]
* INTERF inputs[91]
* INTERF inputs[90]
* INTERF inputs[9]
* INTERF inputs[89]
* INTERF inputs[88]
* INTERF inputs[87]
* INTERF inputs[86]
* INTERF inputs[85]
* INTERF inputs[84]
* INTERF inputs[83]
* INTERF inputs[82]
* INTERF inputs[81]
* INTERF inputs[80]
* INTERF inputs[8]
* INTERF inputs[79]
* INTERF inputs[78]
* INTERF inputs[77]
* INTERF inputs[76]
* INTERF inputs[75]
* INTERF inputs[74]
* INTERF inputs[73]
* INTERF inputs[72]
* INTERF inputs[71]
* INTERF inputs[70]
* INTERF inputs[7]
* INTERF inputs[69]
* INTERF inputs[68]
* INTERF inputs[67]
* INTERF inputs[66]
* INTERF inputs[65]
* INTERF inputs[64]
* INTERF inputs[63]
* INTERF inputs[62]
* INTERF inputs[61]
* INTERF inputs[60]
* INTERF inputs[6]
* INTERF inputs[59]
* INTERF inputs[58]
* INTERF inputs[57]
* INTERF inputs[56]
* INTERF inputs[55]
* INTERF inputs[54]
* INTERF inputs[53]
* INTERF inputs[52]
* INTERF inputs[51]
* INTERF inputs[50]
* INTERF inputs[5]
* INTERF inputs[49]
* INTERF inputs[48]
* INTERF inputs[47]
* INTERF inputs[46]
* INTERF inputs[45]
* INTERF inputs[44]
* INTERF inputs[43]
* INTERF inputs[42]
* INTERF inputs[41]
* INTERF inputs[40]
* INTERF inputs[4]
* INTERF inputs[39]
* INTERF inputs[38]
* INTERF inputs[37]
* INTERF inputs[36]
* INTERF inputs[35]
* INTERF inputs[34]
* INTERF inputs[33]
* INTERF inputs[32]
* INTERF inputs[31]
* INTERF inputs[30]
* INTERF inputs[3]
* INTERF inputs[29]
* INTERF inputs[28]
* INTERF inputs[27]
* INTERF inputs[26]
* INTERF inputs[25]
* INTERF inputs[24]
* INTERF inputs[23]
* INTERF inputs[22]
* INTERF inputs[21]
* INTERF inputs[20]
* INTERF inputs[2]
* INTERF inputs[19]
* INTERF inputs[18]
* INTERF inputs[17]
* INTERF inputs[16]
* INTERF inputs[15]
* INTERF inputs[14]
* INTERF inputs[13]
* INTERF inputs[127]
* INTERF inputs[126]
* INTERF inputs[125]
* INTERF inputs[124]
* INTERF inputs[123]
* INTERF inputs[122]
* INTERF inputs[121]
* INTERF inputs[120]
* INTERF inputs[12]
* INTERF inputs[119]
* INTERF inputs[118]
* INTERF inputs[117]
* INTERF inputs[116]
* INTERF inputs[115]
* INTERF inputs[114]
* INTERF inputs[113]
* INTERF inputs[112]
* INTERF inputs[111]
* INTERF inputs[110]
* INTERF inputs[11]
* INTERF inputs[109]
* INTERF inputs[108]
* INTERF inputs[107]
* INTERF inputs[106]
* INTERF inputs[105]
* INTERF inputs[104]
* INTERF inputs[103]
* INTERF inputs[102]
* INTERF inputs[101]
* INTERF inputs[100]
* INTERF inputs[10]
* INTERF inputs[1]
* INTERF inputs[0]
* INTERF clk

* Terminal models (aka standard cells) used througout all the hierarchy.
.include dff_x1.spi
.include or3_x1.spi
.include and2_x1.spi
.include and3_x1.spi
.include nexor2_x0.spi
.include xor2_x0.spi
.include nor4_x0.spi
.include nand3_x0.spi
.include and4_x1.spi
.include or21nand_x0.spi
.include inv_x0.spi
.include nor2_x0.spi
.include nand2_x0.spi
.include nand4_x0.spi
.include and21nor_x0.spi
.include mux2_x1.spi
.include one_x1.spi

* Non-terminal models (part of the user's design hierarchy).

.subckt expmob2 0 1 2 3 4 5 6 7 8 9 10 11 12 13 14 15 16 17 18 19 20 21 22 23 24 25 26 27 28 29 30 31 32 33 34 35 36 37 38 39 40 41 42 43 44 45 46 47 48 49 50 51 52 53 54 55 56 57 58 59 60 61 62 63 64 65 66 67 68 69 70 71 72 73 74 75 76 77 78 79 80 81 82 83 84 85 86 87 88 89 90 91 92 93 94 95 96 97 98 99 100 101 102 103 104 105 106 107 108 109 110 111 112 113 114 115 116 117 118 119 120 121 122 123 124 125 126 127 128 129 227 228 229 230 231 232 233 234 235 236 237 238 239 240 241 242 243 244 245 246 247 248 249 250 251 252 253 254 255 256 257 258 259 260 261 262 263 264 265 266 267 268 269 270 271 272 273 274 275 276 277 278 279 280 281 282 283 284 285 286 287 288 289 290 291 292 293 294 295 296 297 298 299 300 301 302 303 304 305 306 307 308 309 310 311 312 313 314 315 316 317 318 319 320 321 322 323 324 325 326 327 328 329 330 331 332 333 334 335 336 337 338 339 340 341 342 343 344 345 346 347 348 349 350 351 352 353 354 356
* NET     0 = vss
* NET     1 = vdd
* NET     2 = outputs[99]
* NET     3 = outputs[98]
* NET     4 = outputs[97]
* NET     5 = outputs[96]
* NET     6 = outputs[95]
* NET     7 = outputs[94]
* NET     8 = outputs[93]
* NET     9 = outputs[92]
* NET    10 = outputs[91]
* NET    11 = outputs[90]
* NET    12 = outputs[9]
* NET    13 = outputs[89]
* NET    14 = outputs[88]
* NET    15 = outputs[87]
* NET    16 = outputs[86]
* NET    17 = outputs[85]
* NET    18 = outputs[84]
* NET    19 = outputs[83]
* NET    20 = outputs[82]
* NET    21 = outputs[81]
* NET    22 = outputs[80]
* NET    23 = outputs[8]
* NET    24 = outputs[79]
* NET    25 = outputs[78]
* NET    26 = outputs[77]
* NET    27 = outputs[76]
* NET    28 = outputs[75]
* NET    29 = outputs[74]
* NET    30 = outputs[73]
* NET    31 = outputs[72]
* NET    32 = outputs[71]
* NET    33 = outputs[70]
* NET    34 = outputs[7]
* NET    35 = outputs[69]
* NET    36 = outputs[68]
* NET    37 = outputs[67]
* NET    38 = outputs[66]
* NET    39 = outputs[65]
* NET    40 = outputs[64]
* NET    41 = outputs[63]
* NET    42 = outputs[62]
* NET    43 = outputs[61]
* NET    44 = outputs[60]
* NET    45 = outputs[6]
* NET    46 = outputs[59]
* NET    47 = outputs[58]
* NET    48 = outputs[57]
* NET    49 = outputs[56]
* NET    50 = outputs[55]
* NET    51 = outputs[54]
* NET    52 = outputs[53]
* NET    53 = outputs[52]
* NET    54 = outputs[51]
* NET    55 = outputs[50]
* NET    56 = outputs[5]
* NET    57 = outputs[49]
* NET    58 = outputs[48]
* NET    59 = outputs[47]
* NET    60 = outputs[46]
* NET    61 = outputs[45]
* NET    62 = outputs[44]
* NET    63 = outputs[43]
* NET    64 = outputs[42]
* NET    65 = outputs[41]
* NET    66 = outputs[40]
* NET    67 = outputs[4]
* NET    68 = outputs[39]
* NET    69 = outputs[38]
* NET    70 = outputs[37]
* NET    71 = outputs[36]
* NET    72 = outputs[35]
* NET    73 = outputs[34]
* NET    74 = outputs[33]
* NET    75 = outputs[32]
* NET    76 = outputs[31]
* NET    77 = outputs[30]
* NET    78 = outputs[3]
* NET    79 = outputs[29]
* NET    80 = outputs[28]
* NET    81 = outputs[27]
* NET    82 = outputs[26]
* NET    83 = outputs[25]
* NET    84 = outputs[24]
* NET    85 = outputs[23]
* NET    86 = outputs[22]
* NET    87 = outputs[21]
* NET    88 = outputs[20]
* NET    89 = outputs[2]
* NET    90 = outputs[19]
* NET    91 = outputs[18]
* NET    92 = outputs[17]
* NET    93 = outputs[16]
* NET    94 = outputs[15]
* NET    95 = outputs[14]
* NET    96 = outputs[13]
* NET    97 = outputs[127]
* NET    98 = outputs[126]
* NET    99 = outputs[125]
* NET   100 = outputs[124]
* NET   101 = outputs[123]
* NET   102 = outputs[122]
* NET   103 = outputs[121]
* NET   104 = outputs[120]
* NET   105 = outputs[12]
* NET   106 = outputs[119]
* NET   107 = outputs[118]
* NET   108 = outputs[117]
* NET   109 = outputs[116]
* NET   110 = outputs[115]
* NET   111 = outputs[114]
* NET   112 = outputs[113]
* NET   113 = outputs[112]
* NET   114 = outputs[111]
* NET   115 = outputs[110]
* NET   116 = outputs[11]
* NET   117 = outputs[109]
* NET   118 = outputs[108]
* NET   119 = outputs[107]
* NET   120 = outputs[106]
* NET   121 = outputs[105]
* NET   122 = outputs[104]
* NET   123 = outputs[103]
* NET   124 = outputs[102]
* NET   125 = outputs[101]
* NET   126 = outputs[100]
* NET   127 = outputs[10]
* NET   128 = outputs[1]
* NET   129 = outputs[0]
* NET   130 = one_0
* NET   131 = n[9]
* NET   132 = n[8]
* NET   133 = n[7]
* NET   134 = n[6]
* NET   135 = n[5]
* NET   136 = n[4]
* NET   137 = n[31]
* NET   138 = n[30]
* NET   139 = n[3]
* NET   140 = n[29]
* NET   141 = n[28]
* NET   142 = n[27]
* NET   143 = n[26]
* NET   144 = n[25]
* NET   145 = n[24]
* NET   146 = n[23]
* NET   147 = n[22]
* NET   148 = n[21]
* NET   149 = n[20]
* NET   150 = n[2]
* NET   151 = n[19]
* NET   152 = n[18]
* NET   153 = n[17]
* NET   154 = n[16]
* NET   155 = n[15]
* NET   156 = n[14]
* NET   157 = n[13]
* NET   158 = n[12]
* NET   159 = n[11]
* NET   160 = n[10]
* NET   161 = n[1]
* NET   162 = n[0]
* NET   163 = mem_inputs[99]
* NET   164 = mem_inputs[98]
* NET   165 = mem_inputs[97]
* NET   166 = mem_inputs[96]
* NET   167 = mem_inputs[95]
* NET   168 = mem_inputs[94]
* NET   169 = mem_inputs[93]
* NET   170 = mem_inputs[92]
* NET   171 = mem_inputs[91]
* NET   172 = mem_inputs[90]
* NET   173 = mem_inputs[89]
* NET   174 = mem_inputs[88]
* NET   175 = mem_inputs[87]
* NET   176 = mem_inputs[86]
* NET   177 = mem_inputs[85]
* NET   178 = mem_inputs[84]
* NET   179 = mem_inputs[83]
* NET   180 = mem_inputs[82]
* NET   181 = mem_inputs[81]
* NET   182 = mem_inputs[80]
* NET   183 = mem_inputs[79]
* NET   184 = mem_inputs[78]
* NET   185 = mem_inputs[77]
* NET   186 = mem_inputs[76]
* NET   187 = mem_inputs[75]
* NET   188 = mem_inputs[74]
* NET   189 = mem_inputs[73]
* NET   190 = mem_inputs[72]
* NET   191 = mem_inputs[71]
* NET   192 = mem_inputs[70]
* NET   193 = mem_inputs[69]
* NET   194 = mem_inputs[68]
* NET   195 = mem_inputs[67]
* NET   196 = mem_inputs[66]
* NET   197 = mem_inputs[65]
* NET   198 = mem_inputs[64]
* NET   199 = mem_inputs[127]
* NET   200 = mem_inputs[126]
* NET   201 = mem_inputs[125]
* NET   202 = mem_inputs[124]
* NET   203 = mem_inputs[123]
* NET   204 = mem_inputs[122]
* NET   205 = mem_inputs[121]
* NET   206 = mem_inputs[120]
* NET   207 = mem_inputs[119]
* NET   208 = mem_inputs[118]
* NET   209 = mem_inputs[117]
* NET   210 = mem_inputs[116]
* NET   211 = mem_inputs[115]
* NET   212 = mem_inputs[114]
* NET   213 = mem_inputs[113]
* NET   214 = mem_inputs[112]
* NET   215 = mem_inputs[111]
* NET   216 = mem_inputs[110]
* NET   217 = mem_inputs[109]
* NET   218 = mem_inputs[108]
* NET   219 = mem_inputs[107]
* NET   220 = mem_inputs[106]
* NET   221 = mem_inputs[105]
* NET   222 = mem_inputs[104]
* NET   223 = mem_inputs[103]
* NET   224 = mem_inputs[102]
* NET   225 = mem_inputs[101]
* NET   226 = mem_inputs[100]
* NET   227 = inputs[99]
* NET   228 = inputs[98]
* NET   229 = inputs[97]
* NET   230 = inputs[96]
* NET   231 = inputs[95]
* NET   232 = inputs[94]
* NET   233 = inputs[93]
* NET   234 = inputs[92]
* NET   235 = inputs[91]
* NET   236 = inputs[90]
* NET   237 = inputs[9]
* NET   238 = inputs[89]
* NET   239 = inputs[88]
* NET   240 = inputs[87]
* NET   241 = inputs[86]
* NET   242 = inputs[85]
* NET   243 = inputs[84]
* NET   244 = inputs[83]
* NET   245 = inputs[82]
* NET   246 = inputs[81]
* NET   247 = inputs[80]
* NET   248 = inputs[8]
* NET   249 = inputs[79]
* NET   250 = inputs[78]
* NET   251 = inputs[77]
* NET   252 = inputs[76]
* NET   253 = inputs[75]
* NET   254 = inputs[74]
* NET   255 = inputs[73]
* NET   256 = inputs[72]
* NET   257 = inputs[71]
* NET   258 = inputs[70]
* NET   259 = inputs[7]
* NET   260 = inputs[69]
* NET   261 = inputs[68]
* NET   262 = inputs[67]
* NET   263 = inputs[66]
* NET   264 = inputs[65]
* NET   265 = inputs[64]
* NET   266 = inputs[63]
* NET   267 = inputs[62]
* NET   268 = inputs[61]
* NET   269 = inputs[60]
* NET   270 = inputs[6]
* NET   271 = inputs[59]
* NET   272 = inputs[58]
* NET   273 = inputs[57]
* NET   274 = inputs[56]
* NET   275 = inputs[55]
* NET   276 = inputs[54]
* NET   277 = inputs[53]
* NET   278 = inputs[52]
* NET   279 = inputs[51]
* NET   280 = inputs[50]
* NET   281 = inputs[5]
* NET   282 = inputs[49]
* NET   283 = inputs[48]
* NET   284 = inputs[47]
* NET   285 = inputs[46]
* NET   286 = inputs[45]
* NET   287 = inputs[44]
* NET   288 = inputs[43]
* NET   289 = inputs[42]
* NET   290 = inputs[41]
* NET   291 = inputs[40]
* NET   292 = inputs[4]
* NET   293 = inputs[39]
* NET   294 = inputs[38]
* NET   295 = inputs[37]
* NET   296 = inputs[36]
* NET   297 = inputs[35]
* NET   298 = inputs[34]
* NET   299 = inputs[33]
* NET   300 = inputs[32]
* NET   301 = inputs[31]
* NET   302 = inputs[30]
* NET   303 = inputs[3]
* NET   304 = inputs[29]
* NET   305 = inputs[28]
* NET   306 = inputs[27]
* NET   307 = inputs[26]
* NET   308 = inputs[25]
* NET   309 = inputs[24]
* NET   310 = inputs[23]
* NET   311 = inputs[22]
* NET   312 = inputs[21]
* NET   313 = inputs[20]
* NET   314 = inputs[2]
* NET   315 = inputs[19]
* NET   316 = inputs[18]
* NET   317 = inputs[17]
* NET   318 = inputs[16]
* NET   319 = inputs[15]
* NET   320 = inputs[14]
* NET   321 = inputs[13]
* NET   322 = inputs[127]
* NET   323 = inputs[126]
* NET   324 = inputs[125]
* NET   325 = inputs[124]
* NET   326 = inputs[123]
* NET   327 = inputs[122]
* NET   328 = inputs[121]
* NET   329 = inputs[120]
* NET   330 = inputs[12]
* NET   331 = inputs[119]
* NET   332 = inputs[118]
* NET   333 = inputs[117]
* NET   334 = inputs[116]
* NET   335 = inputs[115]
* NET   336 = inputs[114]
* NET   337 = inputs[113]
* NET   338 = inputs[112]
* NET   339 = inputs[111]
* NET   340 = inputs[110]
* NET   341 = inputs[11]
* NET   342 = inputs[109]
* NET   343 = inputs[108]
* NET   344 = inputs[107]
* NET   345 = inputs[106]
* NET   346 = inputs[105]
* NET   347 = inputs[104]
* NET   348 = inputs[103]
* NET   349 = inputs[102]
* NET   350 = inputs[101]
* NET   351 = inputs[100]
* NET   352 = inputs[10]
* NET   353 = inputs[1]
* NET   354 = inputs[0]
* NET   355 = init
* NET   356 = clk
* NET   357 = abc_2169_new_n999
* NET   358 = abc_2169_new_n997
* NET   359 = abc_2169_new_n996
* NET   360 = abc_2169_new_n995
* NET   361 = abc_2169_new_n993
* NET   362 = abc_2169_new_n992
* NET   363 = abc_2169_new_n991
* NET   364 = abc_2169_new_n989
* NET   365 = abc_2169_new_n988
* NET   366 = abc_2169_new_n987
* NET   367 = abc_2169_new_n985
* NET   368 = abc_2169_new_n984
* NET   369 = abc_2169_new_n983
* NET   370 = abc_2169_new_n981
* NET   371 = abc_2169_new_n980
* NET   372 = abc_2169_new_n979
* NET   373 = abc_2169_new_n977
* NET   374 = abc_2169_new_n976
* NET   375 = abc_2169_new_n975
* NET   376 = abc_2169_new_n973
* NET   377 = abc_2169_new_n972
* NET   378 = abc_2169_new_n971
* NET   379 = abc_2169_new_n969
* NET   380 = abc_2169_new_n968
* NET   381 = abc_2169_new_n967
* NET   382 = abc_2169_new_n965
* NET   383 = abc_2169_new_n964
* NET   384 = abc_2169_new_n963
* NET   385 = abc_2169_new_n961
* NET   386 = abc_2169_new_n960
* NET   387 = abc_2169_new_n959
* NET   388 = abc_2169_new_n957
* NET   389 = abc_2169_new_n956
* NET   390 = abc_2169_new_n955
* NET   391 = abc_2169_new_n953
* NET   392 = abc_2169_new_n952
* NET   393 = abc_2169_new_n951
* NET   394 = abc_2169_new_n949
* NET   395 = abc_2169_new_n948
* NET   396 = abc_2169_new_n947
* NET   397 = abc_2169_new_n945
* NET   398 = abc_2169_new_n944
* NET   399 = abc_2169_new_n943
* NET   400 = abc_2169_new_n941
* NET   401 = abc_2169_new_n940
* NET   402 = abc_2169_new_n939
* NET   403 = abc_2169_new_n937
* NET   404 = abc_2169_new_n936
* NET   405 = abc_2169_new_n935
* NET   406 = abc_2169_new_n933
* NET   407 = abc_2169_new_n932
* NET   408 = abc_2169_new_n931
* NET   409 = abc_2169_new_n929
* NET   410 = abc_2169_new_n928
* NET   411 = abc_2169_new_n927
* NET   412 = abc_2169_new_n925
* NET   413 = abc_2169_new_n924
* NET   414 = abc_2169_new_n923
* NET   415 = abc_2169_new_n921
* NET   416 = abc_2169_new_n920
* NET   417 = abc_2169_new_n919
* NET   418 = abc_2169_new_n917
* NET   419 = abc_2169_new_n916
* NET   420 = abc_2169_new_n915
* NET   421 = abc_2169_new_n913
* NET   422 = abc_2169_new_n912
* NET   423 = abc_2169_new_n911
* NET   424 = abc_2169_new_n909
* NET   425 = abc_2169_new_n908
* NET   426 = abc_2169_new_n907
* NET   427 = abc_2169_new_n905
* NET   428 = abc_2169_new_n904
* NET   429 = abc_2169_new_n903
* NET   430 = abc_2169_new_n901
* NET   431 = abc_2169_new_n900
* NET   432 = abc_2169_new_n899
* NET   433 = abc_2169_new_n897
* NET   434 = abc_2169_new_n896
* NET   435 = abc_2169_new_n895
* NET   436 = abc_2169_new_n893
* NET   437 = abc_2169_new_n892
* NET   438 = abc_2169_new_n891
* NET   439 = abc_2169_new_n889
* NET   440 = abc_2169_new_n888
* NET   441 = abc_2169_new_n887
* NET   442 = abc_2169_new_n885
* NET   443 = abc_2169_new_n884
* NET   444 = abc_2169_new_n883
* NET   445 = abc_2169_new_n881
* NET   446 = abc_2169_new_n880
* NET   447 = abc_2169_new_n879
* NET   448 = abc_2169_new_n877
* NET   449 = abc_2169_new_n876
* NET   450 = abc_2169_new_n875
* NET   451 = abc_2169_new_n873
* NET   452 = abc_2169_new_n872
* NET   453 = abc_2169_new_n871
* NET   454 = abc_2169_new_n869
* NET   455 = abc_2169_new_n868
* NET   456 = abc_2169_new_n867
* NET   457 = abc_2169_new_n865
* NET   458 = abc_2169_new_n864
* NET   459 = abc_2169_new_n863
* NET   460 = abc_2169_new_n861
* NET   461 = abc_2169_new_n860
* NET   462 = abc_2169_new_n859
* NET   463 = abc_2169_new_n857
* NET   464 = abc_2169_new_n856
* NET   465 = abc_2169_new_n855
* NET   466 = abc_2169_new_n853
* NET   467 = abc_2169_new_n852
* NET   468 = abc_2169_new_n851
* NET   469 = abc_2169_new_n849
* NET   470 = abc_2169_new_n848
* NET   471 = abc_2169_new_n847
* NET   472 = abc_2169_new_n845
* NET   473 = abc_2169_new_n844
* NET   474 = abc_2169_new_n843
* NET   475 = abc_2169_new_n841
* NET   476 = abc_2169_new_n840
* NET   477 = abc_2169_new_n839
* NET   478 = abc_2169_new_n837
* NET   479 = abc_2169_new_n836
* NET   480 = abc_2169_new_n835
* NET   481 = abc_2169_new_n833
* NET   482 = abc_2169_new_n832
* NET   483 = abc_2169_new_n831
* NET   484 = abc_2169_new_n829
* NET   485 = abc_2169_new_n828
* NET   486 = abc_2169_new_n827
* NET   487 = abc_2169_new_n825
* NET   488 = abc_2169_new_n824
* NET   489 = abc_2169_new_n823
* NET   490 = abc_2169_new_n821
* NET   491 = abc_2169_new_n820
* NET   492 = abc_2169_new_n819
* NET   493 = abc_2169_new_n817
* NET   494 = abc_2169_new_n816
* NET   495 = abc_2169_new_n815
* NET   496 = abc_2169_new_n813
* NET   497 = abc_2169_new_n812
* NET   498 = abc_2169_new_n811
* NET   499 = abc_2169_new_n809
* NET   500 = abc_2169_new_n808
* NET   501 = abc_2169_new_n807
* NET   502 = abc_2169_new_n805
* NET   503 = abc_2169_new_n804
* NET   504 = abc_2169_new_n803
* NET   505 = abc_2169_new_n801
* NET   506 = abc_2169_new_n800
* NET   507 = abc_2169_new_n799
* NET   508 = abc_2169_new_n797
* NET   509 = abc_2169_new_n796
* NET   510 = abc_2169_new_n795
* NET   511 = abc_2169_new_n793
* NET   512 = abc_2169_new_n792
* NET   513 = abc_2169_new_n791
* NET   514 = abc_2169_new_n789
* NET   515 = abc_2169_new_n788
* NET   516 = abc_2169_new_n787
* NET   517 = abc_2169_new_n785
* NET   518 = abc_2169_new_n784
* NET   519 = abc_2169_new_n783
* NET   520 = abc_2169_new_n781
* NET   521 = abc_2169_new_n780
* NET   522 = abc_2169_new_n779
* NET   523 = abc_2169_new_n777
* NET   524 = abc_2169_new_n776
* NET   525 = abc_2169_new_n775
* NET   526 = abc_2169_new_n773
* NET   527 = abc_2169_new_n772
* NET   528 = abc_2169_new_n771
* NET   529 = abc_2169_new_n769
* NET   530 = abc_2169_new_n768
* NET   531 = abc_2169_new_n767
* NET   532 = abc_2169_new_n765
* NET   533 = abc_2169_new_n764
* NET   534 = abc_2169_new_n763
* NET   535 = abc_2169_new_n761
* NET   536 = abc_2169_new_n760
* NET   537 = abc_2169_new_n759
* NET   538 = abc_2169_new_n757
* NET   539 = abc_2169_new_n756
* NET   540 = abc_2169_new_n755
* NET   541 = abc_2169_new_n753
* NET   542 = abc_2169_new_n752
* NET   543 = abc_2169_new_n751
* NET   544 = abc_2169_new_n749
* NET   545 = abc_2169_new_n748
* NET   546 = abc_2169_new_n747
* NET   547 = abc_2169_new_n745
* NET   548 = abc_2169_new_n744
* NET   549 = abc_2169_new_n743
* NET   550 = abc_2169_new_n741
* NET   551 = abc_2169_new_n740
* NET   552 = abc_2169_new_n739
* NET   553 = abc_2169_new_n737
* NET   554 = abc_2169_new_n736
* NET   555 = abc_2169_new_n735
* NET   556 = abc_2169_new_n733
* NET   557 = abc_2169_new_n732
* NET   558 = abc_2169_new_n731
* NET   559 = abc_2169_new_n729
* NET   560 = abc_2169_new_n728
* NET   561 = abc_2169_new_n727
* NET   562 = abc_2169_new_n725
* NET   563 = abc_2169_new_n724
* NET   564 = abc_2169_new_n723
* NET   565 = abc_2169_new_n721
* NET   566 = abc_2169_new_n720
* NET   567 = abc_2169_new_n719
* NET   568 = abc_2169_new_n717
* NET   569 = abc_2169_new_n716
* NET   570 = abc_2169_new_n715
* NET   571 = abc_2169_new_n713
* NET   572 = abc_2169_new_n712
* NET   573 = abc_2169_new_n711
* NET   574 = abc_2169_new_n709
* NET   575 = abc_2169_new_n708
* NET   576 = abc_2169_new_n707
* NET   577 = abc_2169_new_n705
* NET   578 = abc_2169_new_n704
* NET   579 = abc_2169_new_n703
* NET   580 = abc_2169_new_n701
* NET   581 = abc_2169_new_n700
* NET   582 = abc_2169_new_n699
* NET   583 = abc_2169_new_n697
* NET   584 = abc_2169_new_n696
* NET   585 = abc_2169_new_n695
* NET   586 = abc_2169_new_n693
* NET   587 = abc_2169_new_n692
* NET   588 = abc_2169_new_n691
* NET   589 = abc_2169_new_n689
* NET   590 = abc_2169_new_n688
* NET   591 = abc_2169_new_n687
* NET   592 = abc_2169_new_n685
* NET   593 = abc_2169_new_n684
* NET   594 = abc_2169_new_n683
* NET   595 = abc_2169_new_n681
* NET   596 = abc_2169_new_n680
* NET   597 = abc_2169_new_n679
* NET   598 = abc_2169_new_n677
* NET   599 = abc_2169_new_n676
* NET   600 = abc_2169_new_n675
* NET   601 = abc_2169_new_n673
* NET   602 = abc_2169_new_n672
* NET   603 = abc_2169_new_n671
* NET   604 = abc_2169_new_n669
* NET   605 = abc_2169_new_n668
* NET   606 = abc_2169_new_n667
* NET   607 = abc_2169_new_n665
* NET   608 = abc_2169_new_n664
* NET   609 = abc_2169_new_n663
* NET   610 = abc_2169_new_n661
* NET   611 = abc_2169_new_n660
* NET   612 = abc_2169_new_n659
* NET   613 = abc_2169_new_n657
* NET   614 = abc_2169_new_n656
* NET   615 = abc_2169_new_n655
* NET   616 = abc_2169_new_n653
* NET   617 = abc_2169_new_n652
* NET   618 = abc_2169_new_n651
* NET   619 = abc_2169_new_n649
* NET   620 = abc_2169_new_n648
* NET   621 = abc_2169_new_n647
* NET   622 = abc_2169_new_n645
* NET   623 = abc_2169_new_n644
* NET   624 = abc_2169_new_n643
* NET   625 = abc_2169_new_n641
* NET   626 = abc_2169_new_n640
* NET   627 = abc_2169_new_n639
* NET   628 = abc_2169_new_n637
* NET   629 = abc_2169_new_n636
* NET   630 = abc_2169_new_n635
* NET   631 = abc_2169_new_n633
* NET   632 = abc_2169_new_n632
* NET   633 = abc_2169_new_n631
* NET   634 = abc_2169_new_n629
* NET   635 = abc_2169_new_n628
* NET   636 = abc_2169_new_n627
* NET   637 = abc_2169_new_n625
* NET   638 = abc_2169_new_n624
* NET   639 = abc_2169_new_n623
* NET   640 = abc_2169_new_n622
* NET   641 = abc_2169_new_n621
* NET   642 = abc_2169_new_n620
* NET   643 = abc_2169_new_n619
* NET   644 = abc_2169_new_n618
* NET   645 = abc_2169_new_n617
* NET   646 = abc_2169_new_n616
* NET   647 = abc_2169_new_n615
* NET   648 = abc_2169_new_n614
* NET   649 = abc_2169_new_n613
* NET   650 = abc_2169_new_n612
* NET   651 = abc_2169_new_n611
* NET   652 = abc_2169_new_n610
* NET   653 = abc_2169_new_n609
* NET   654 = abc_2169_new_n608
* NET   655 = abc_2169_new_n607
* NET   656 = abc_2169_new_n606
* NET   657 = abc_2169_new_n541
* NET   658 = abc_2169_new_n540
* NET   659 = abc_2169_new_n539
* NET   660 = abc_2169_new_n538
* NET   661 = abc_2169_new_n537
* NET   662 = abc_2169_new_n536
* NET   663 = abc_2169_new_n535
* NET   664 = abc_2169_new_n534
* NET   665 = abc_2169_new_n533
* NET   666 = abc_2169_new_n532
* NET   667 = abc_2169_new_n531
* NET   668 = abc_2169_new_n530
* NET   669 = abc_2169_new_n529
* NET   670 = abc_2169_new_n528
* NET   671 = abc_2169_new_n527
* NET   672 = abc_2169_new_n526
* NET   673 = abc_2169_new_n525
* NET   674 = abc_2169_new_n524
* NET   675 = abc_2169_new_n523
* NET   676 = abc_2169_new_n522
* NET   677 = abc_2169_new_n521
* NET   678 = abc_2169_new_n520
* NET   679 = abc_2169_new_n519
* NET   680 = abc_2169_new_n518
* NET   681 = abc_2169_new_n517
* NET   682 = abc_2169_new_n516
* NET   683 = abc_2169_new_n515
* NET   684 = abc_2169_new_n514
* NET   685 = abc_2169_new_n1204
* NET   686 = abc_2169_new_n1202
* NET   687 = abc_2169_new_n1201
* NET   688 = abc_2169_new_n1200
* NET   689 = abc_2169_new_n1199
* NET   690 = abc_2169_new_n1196
* NET   691 = abc_2169_new_n1194
* NET   692 = abc_2169_new_n1192
* NET   693 = abc_2169_new_n1191
* NET   694 = abc_2169_new_n1190
* NET   695 = abc_2169_new_n1187
* NET   696 = abc_2169_new_n1185
* NET   697 = abc_2169_new_n1184
* NET   698 = abc_2169_new_n1182
* NET   699 = abc_2169_new_n1181
* NET   700 = abc_2169_new_n1180
* NET   701 = abc_2169_new_n1179
* NET   702 = abc_2169_new_n1178
* NET   703 = abc_2169_new_n1177
* NET   704 = abc_2169_new_n1176
* NET   705 = abc_2169_new_n1173
* NET   706 = abc_2169_new_n1171
* NET   707 = abc_2169_new_n1170
* NET   708 = abc_2169_new_n1168
* NET   709 = abc_2169_new_n1166
* NET   710 = abc_2169_new_n1164
* NET   711 = abc_2169_new_n1162
* NET   712 = abc_2169_new_n1160
* NET   713 = abc_2169_new_n1158
* NET   714 = abc_2169_new_n1157
* NET   715 = abc_2169_new_n1156
* NET   716 = abc_2169_new_n1155
* NET   717 = abc_2169_new_n1153
* NET   718 = abc_2169_new_n1151
* NET   719 = abc_2169_new_n1149
* NET   720 = abc_2169_new_n1147
* NET   721 = abc_2169_new_n1145
* NET   722 = abc_2169_new_n1143
* NET   723 = abc_2169_new_n1142
* NET   724 = abc_2169_new_n1141
* NET   725 = abc_2169_new_n1138
* NET   726 = abc_2169_new_n1136
* NET   727 = abc_2169_new_n1134
* NET   728 = abc_2169_new_n1132
* NET   729 = abc_2169_new_n1129
* NET   730 = abc_2169_new_n1128
* NET   731 = abc_2169_new_n1127
* NET   732 = abc_2169_new_n1125
* NET   733 = abc_2169_new_n1124
* NET   734 = abc_2169_new_n1123
* NET   735 = abc_2169_new_n1121
* NET   736 = abc_2169_new_n1120
* NET   737 = abc_2169_new_n1119
* NET   738 = abc_2169_new_n1117
* NET   739 = abc_2169_new_n1116
* NET   740 = abc_2169_new_n1115
* NET   741 = abc_2169_new_n1113
* NET   742 = abc_2169_new_n1112
* NET   743 = abc_2169_new_n1111
* NET   744 = abc_2169_new_n1109
* NET   745 = abc_2169_new_n1108
* NET   746 = abc_2169_new_n1107
* NET   747 = abc_2169_new_n1105
* NET   748 = abc_2169_new_n1104
* NET   749 = abc_2169_new_n1103
* NET   750 = abc_2169_new_n1101
* NET   751 = abc_2169_new_n1100
* NET   752 = abc_2169_new_n1099
* NET   753 = abc_2169_new_n1097
* NET   754 = abc_2169_new_n1096
* NET   755 = abc_2169_new_n1095
* NET   756 = abc_2169_new_n1093
* NET   757 = abc_2169_new_n1092
* NET   758 = abc_2169_new_n1091
* NET   759 = abc_2169_new_n1089
* NET   760 = abc_2169_new_n1088
* NET   761 = abc_2169_new_n1087
* NET   762 = abc_2169_new_n1085
* NET   763 = abc_2169_new_n1084
* NET   764 = abc_2169_new_n1083
* NET   765 = abc_2169_new_n1081
* NET   766 = abc_2169_new_n1080
* NET   767 = abc_2169_new_n1079
* NET   768 = abc_2169_new_n1077
* NET   769 = abc_2169_new_n1076
* NET   770 = abc_2169_new_n1075
* NET   771 = abc_2169_new_n1073
* NET   772 = abc_2169_new_n1072
* NET   773 = abc_2169_new_n1071
* NET   774 = abc_2169_new_n1069
* NET   775 = abc_2169_new_n1068
* NET   776 = abc_2169_new_n1067
* NET   777 = abc_2169_new_n1065
* NET   778 = abc_2169_new_n1064
* NET   779 = abc_2169_new_n1063
* NET   780 = abc_2169_new_n1061
* NET   781 = abc_2169_new_n1060
* NET   782 = abc_2169_new_n1059
* NET   783 = abc_2169_new_n1057
* NET   784 = abc_2169_new_n1056
* NET   785 = abc_2169_new_n1055
* NET   786 = abc_2169_new_n1053
* NET   787 = abc_2169_new_n1052
* NET   788 = abc_2169_new_n1051
* NET   789 = abc_2169_new_n1049
* NET   790 = abc_2169_new_n1048
* NET   791 = abc_2169_new_n1047
* NET   792 = abc_2169_new_n1045
* NET   793 = abc_2169_new_n1044
* NET   794 = abc_2169_new_n1043
* NET   795 = abc_2169_new_n1041
* NET   796 = abc_2169_new_n1040
* NET   797 = abc_2169_new_n1039
* NET   798 = abc_2169_new_n1037
* NET   799 = abc_2169_new_n1036
* NET   800 = abc_2169_new_n1035
* NET   801 = abc_2169_new_n1033
* NET   802 = abc_2169_new_n1032
* NET   803 = abc_2169_new_n1031
* NET   804 = abc_2169_new_n1029
* NET   805 = abc_2169_new_n1028
* NET   806 = abc_2169_new_n1027
* NET   807 = abc_2169_new_n1025
* NET   808 = abc_2169_new_n1024
* NET   809 = abc_2169_new_n1023
* NET   810 = abc_2169_new_n1021
* NET   811 = abc_2169_new_n1020
* NET   812 = abc_2169_new_n1019
* NET   813 = abc_2169_new_n1017
* NET   814 = abc_2169_new_n1016
* NET   815 = abc_2169_new_n1015
* NET   816 = abc_2169_new_n1013
* NET   817 = abc_2169_new_n1012
* NET   818 = abc_2169_new_n1011
* NET   819 = abc_2169_new_n1009
* NET   820 = abc_2169_new_n1008
* NET   821 = abc_2169_new_n1007
* NET   822 = abc_2169_new_n1005
* NET   823 = abc_2169_new_n1004
* NET   824 = abc_2169_new_n1003
* NET   825 = abc_2169_new_n1001
* NET   826 = abc_2169_new_n1000
* NET   827 = abc_2169_auto_rtlil_cc_2739_MuxGate_2168
* NET   828 = abc_2169_auto_rtlil_cc_2739_MuxGate_2166
* NET   829 = abc_2169_auto_rtlil_cc_2739_MuxGate_2164
* NET   830 = abc_2169_auto_rtlil_cc_2739_MuxGate_2162
* NET   831 = abc_2169_auto_rtlil_cc_2739_MuxGate_2160
* NET   832 = abc_2169_auto_rtlil_cc_2739_MuxGate_2158
* NET   833 = abc_2169_auto_rtlil_cc_2739_MuxGate_2156
* NET   834 = abc_2169_auto_rtlil_cc_2739_MuxGate_2154
* NET   835 = abc_2169_auto_rtlil_cc_2739_MuxGate_2152
* NET   836 = abc_2169_auto_rtlil_cc_2739_MuxGate_2150
* NET   837 = abc_2169_auto_rtlil_cc_2739_MuxGate_2148
* NET   838 = abc_2169_auto_rtlil_cc_2739_MuxGate_2146
* NET   839 = abc_2169_auto_rtlil_cc_2739_MuxGate_2144
* NET   840 = abc_2169_auto_rtlil_cc_2739_MuxGate_2142
* NET   841 = abc_2169_auto_rtlil_cc_2739_MuxGate_2140
* NET   842 = abc_2169_auto_rtlil_cc_2739_MuxGate_2138
* NET   843 = abc_2169_auto_rtlil_cc_2739_MuxGate_2136
* NET   844 = abc_2169_auto_rtlil_cc_2739_MuxGate_2134
* NET   845 = abc_2169_auto_rtlil_cc_2739_MuxGate_2132
* NET   846 = abc_2169_auto_rtlil_cc_2739_MuxGate_2130
* NET   847 = abc_2169_auto_rtlil_cc_2739_MuxGate_2128
* NET   848 = abc_2169_auto_rtlil_cc_2739_MuxGate_2126
* NET   849 = abc_2169_auto_rtlil_cc_2739_MuxGate_2124
* NET   850 = abc_2169_auto_rtlil_cc_2739_MuxGate_2122
* NET   851 = abc_2169_auto_rtlil_cc_2739_MuxGate_2120
* NET   852 = abc_2169_auto_rtlil_cc_2739_MuxGate_2118
* NET   853 = abc_2169_auto_rtlil_cc_2739_MuxGate_2116
* NET   854 = abc_2169_auto_rtlil_cc_2739_MuxGate_2114
* NET   855 = abc_2169_auto_rtlil_cc_2739_MuxGate_2112
* NET   856 = abc_2169_auto_rtlil_cc_2739_MuxGate_2110
* NET   857 = abc_2169_auto_rtlil_cc_2739_MuxGate_2108
* NET   858 = abc_2169_auto_rtlil_cc_2739_MuxGate_2106
* NET   859 = abc_2169_auto_rtlil_cc_2739_MuxGate_2104
* NET   860 = abc_2169_auto_rtlil_cc_2739_MuxGate_2102
* NET   861 = abc_2169_auto_rtlil_cc_2739_MuxGate_2100
* NET   862 = abc_2169_auto_rtlil_cc_2739_MuxGate_2098
* NET   863 = abc_2169_auto_rtlil_cc_2739_MuxGate_2096
* NET   864 = abc_2169_auto_rtlil_cc_2739_MuxGate_2094
* NET   865 = abc_2169_auto_rtlil_cc_2739_MuxGate_2092
* NET   866 = abc_2169_auto_rtlil_cc_2739_MuxGate_2090
* NET   867 = abc_2169_auto_rtlil_cc_2739_MuxGate_2088
* NET   868 = abc_2169_auto_rtlil_cc_2739_MuxGate_2086
* NET   869 = abc_2169_auto_rtlil_cc_2739_MuxGate_2084
* NET   870 = abc_2169_auto_rtlil_cc_2739_MuxGate_2082
* NET   871 = abc_2169_auto_rtlil_cc_2739_MuxGate_2080
* NET   872 = abc_2169_auto_rtlil_cc_2739_MuxGate_2078
* NET   873 = abc_2169_auto_rtlil_cc_2739_MuxGate_2076
* NET   874 = abc_2169_auto_rtlil_cc_2739_MuxGate_2074
* NET   875 = abc_2169_auto_rtlil_cc_2739_MuxGate_2072
* NET   876 = abc_2169_auto_rtlil_cc_2739_MuxGate_2070
* NET   877 = abc_2169_auto_rtlil_cc_2739_MuxGate_2068
* NET   878 = abc_2169_auto_rtlil_cc_2739_MuxGate_2066
* NET   879 = abc_2169_auto_rtlil_cc_2739_MuxGate_2064
* NET   880 = abc_2169_auto_rtlil_cc_2739_MuxGate_2062
* NET   881 = abc_2169_auto_rtlil_cc_2739_MuxGate_2060
* NET   882 = abc_2169_auto_rtlil_cc_2739_MuxGate_2058
* NET   883 = abc_2169_auto_rtlil_cc_2739_MuxGate_2056
* NET   884 = abc_2169_auto_rtlil_cc_2739_MuxGate_2054
* NET   885 = abc_2169_auto_rtlil_cc_2739_MuxGate_2052
* NET   886 = abc_2169_auto_rtlil_cc_2739_MuxGate_2050
* NET   887 = abc_2169_auto_rtlil_cc_2739_MuxGate_2048
* NET   888 = abc_2169_auto_rtlil_cc_2739_MuxGate_2046
* NET   889 = abc_2169_auto_rtlil_cc_2739_MuxGate_2044
* NET   890 = abc_2169_auto_rtlil_cc_2739_MuxGate_2042
* NET   891 = abc_2169_auto_rtlil_cc_2739_MuxGate_2040
* NET   892 = abc_2169_auto_rtlil_cc_2739_MuxGate_2038
* NET   893 = abc_2169_auto_rtlil_cc_2739_MuxGate_2036
* NET   894 = abc_2169_auto_rtlil_cc_2739_MuxGate_2034
* NET   895 = abc_2169_auto_rtlil_cc_2739_MuxGate_2032
* NET   896 = abc_2169_auto_rtlil_cc_2739_MuxGate_2030
* NET   897 = abc_2169_auto_rtlil_cc_2739_MuxGate_2028
* NET   898 = abc_2169_auto_rtlil_cc_2739_MuxGate_2026
* NET   899 = abc_2169_auto_rtlil_cc_2739_MuxGate_2024
* NET   900 = abc_2169_auto_rtlil_cc_2739_MuxGate_2022
* NET   901 = abc_2169_auto_rtlil_cc_2739_MuxGate_2020
* NET   902 = abc_2169_auto_rtlil_cc_2739_MuxGate_2018
* NET   903 = abc_2169_auto_rtlil_cc_2739_MuxGate_2016
* NET   904 = abc_2169_auto_rtlil_cc_2739_MuxGate_2014
* NET   905 = abc_2169_auto_rtlil_cc_2739_MuxGate_2012
* NET   906 = abc_2169_auto_rtlil_cc_2739_MuxGate_2010
* NET   907 = abc_2169_auto_rtlil_cc_2739_MuxGate_2008
* NET   908 = abc_2169_auto_rtlil_cc_2739_MuxGate_2006
* NET   909 = abc_2169_auto_rtlil_cc_2739_MuxGate_2004
* NET   910 = abc_2169_auto_rtlil_cc_2739_MuxGate_2002
* NET   911 = abc_2169_auto_rtlil_cc_2739_MuxGate_2000
* NET   912 = abc_2169_auto_rtlil_cc_2739_MuxGate_1998
* NET   913 = abc_2169_auto_rtlil_cc_2739_MuxGate_1996
* NET   914 = abc_2169_auto_rtlil_cc_2739_MuxGate_1994
* NET   915 = abc_2169_auto_rtlil_cc_2739_MuxGate_1992
* NET   916 = abc_2169_auto_rtlil_cc_2739_MuxGate_1990
* NET   917 = abc_2169_auto_rtlil_cc_2739_MuxGate_1988
* NET   918 = abc_2169_auto_rtlil_cc_2739_MuxGate_1986
* NET   919 = abc_2169_auto_rtlil_cc_2739_MuxGate_1984
* NET   920 = abc_2169_auto_rtlil_cc_2739_MuxGate_1982
* NET   921 = abc_2169_auto_rtlil_cc_2739_MuxGate_1980
* NET   922 = abc_2169_auto_rtlil_cc_2739_MuxGate_1978
* NET   923 = abc_2169_auto_rtlil_cc_2739_MuxGate_1976
* NET   924 = abc_2169_auto_rtlil_cc_2739_MuxGate_1974
* NET   925 = abc_2169_auto_rtlil_cc_2739_MuxGate_1972
* NET   926 = abc_2169_auto_rtlil_cc_2739_MuxGate_1970
* NET   927 = abc_2169_auto_rtlil_cc_2739_MuxGate_1968
* NET   928 = abc_2169_auto_rtlil_cc_2739_MuxGate_1966
* NET   929 = abc_2169_auto_rtlil_cc_2739_MuxGate_1964
* NET   930 = abc_2169_auto_rtlil_cc_2739_MuxGate_1962
* NET   931 = abc_2169_auto_rtlil_cc_2739_MuxGate_1960
* NET   932 = abc_2169_auto_rtlil_cc_2739_MuxGate_1958
* NET   933 = abc_2169_auto_rtlil_cc_2739_MuxGate_1956
* NET   934 = abc_2169_auto_rtlil_cc_2739_MuxGate_1954
* NET   935 = abc_2169_auto_rtlil_cc_2739_MuxGate_1952
* NET   936 = abc_2169_auto_rtlil_cc_2739_MuxGate_1950
* NET   937 = abc_2169_auto_rtlil_cc_2739_MuxGate_1948
* NET   938 = abc_2169_auto_rtlil_cc_2739_MuxGate_1946
* NET   939 = abc_2169_auto_rtlil_cc_2739_MuxGate_1944
* NET   940 = abc_2169_auto_rtlil_cc_2739_MuxGate_1942
* NET   941 = abc_2169_auto_rtlil_cc_2739_MuxGate_1940
* NET   942 = abc_2169_auto_rtlil_cc_2739_MuxGate_1938
* NET   943 = abc_2169_auto_rtlil_cc_2739_MuxGate_1936
* NET   944 = abc_2169_auto_rtlil_cc_2739_MuxGate_1934
* NET   945 = abc_2169_auto_rtlil_cc_2739_MuxGate_1932
* NET   946 = abc_2169_auto_rtlil_cc_2739_MuxGate_1930
* NET   947 = abc_2169_auto_rtlil_cc_2739_MuxGate_1928
* NET   948 = abc_2169_auto_rtlil_cc_2739_MuxGate_1926
* NET   949 = abc_2169_auto_rtlil_cc_2739_MuxGate_1924
* NET   950 = abc_2169_auto_rtlil_cc_2739_MuxGate_1922
* NET   951 = abc_2169_auto_rtlil_cc_2739_MuxGate_1920
* NET   952 = abc_2169_auto_rtlil_cc_2739_MuxGate_1918
* NET   953 = abc_2169_auto_rtlil_cc_2739_MuxGate_1916
* NET   954 = abc_2169_auto_rtlil_cc_2739_MuxGate_1914
* NET   955 = abc_2169_auto_rtlil_cc_2739_MuxGate_1912
* NET   956 = abc_2169_auto_rtlil_cc_2739_MuxGate_1910
* NET   957 = abc_2169_auto_rtlil_cc_2739_MuxGate_1908
* NET   958 = abc_2169_auto_rtlil_cc_2739_MuxGate_1906
* NET   959 = abc_2169_auto_rtlil_cc_2739_MuxGate_1904
* NET   960 = abc_2169_auto_rtlil_cc_2739_MuxGate_1902
* NET   961 = abc_2169_auto_rtlil_cc_2739_MuxGate_1900
* NET   962 = abc_2169_auto_rtlil_cc_2739_MuxGate_1898
* NET   963 = abc_2169_auto_rtlil_cc_2739_MuxGate_1896
* NET   964 = abc_2169_auto_rtlil_cc_2739_MuxGate_1894
* NET   965 = abc_2169_auto_rtlil_cc_2739_MuxGate_1892
* NET   966 = abc_2169_auto_rtlil_cc_2739_MuxGate_1890
* NET   967 = abc_2169_auto_rtlil_cc_2739_MuxGate_1888
* NET   968 = abc_2169_auto_rtlil_cc_2739_MuxGate_1886
* NET   969 = abc_2169_auto_rtlil_cc_2739_MuxGate_1884
* NET   970 = abc_2169_auto_rtlil_cc_2739_MuxGate_1882
* NET   971 = abc_2169_auto_rtlil_cc_2739_MuxGate_1880
* NET   972 = abc_2169_auto_rtlil_cc_2739_MuxGate_1878
* NET   973 = abc_2169_auto_rtlil_cc_2739_MuxGate_1876
* NET   974 = abc_2169_auto_rtlil_cc_2739_MuxGate_1874
* NET   975 = abc_2169_auto_rtlil_cc_2739_MuxGate_1872
* NET   976 = abc_2169_auto_rtlil_cc_2739_MuxGate_1870
* NET   977 = abc_2169_auto_rtlil_cc_2739_MuxGate_1868
* NET   978 = abc_2169_auto_rtlil_cc_2739_MuxGate_1866
* NET   979 = abc_2169_auto_rtlil_cc_2739_MuxGate_1864
* NET   980 = abc_2169_auto_rtlil_cc_2739_MuxGate_1862
* NET   981 = abc_2169_auto_rtlil_cc_2739_MuxGate_1860
* NET   982 = abc_2169_auto_rtlil_cc_2739_MuxGate_1858
* NET   983 = abc_2169_auto_rtlil_cc_2739_MuxGate_1856
* NET   984 = abc_2169_auto_rtlil_cc_2739_MuxGate_1854
* NET   985 = abc_2169_auto_rtlil_cc_2739_MuxGate_1852
* NET   986 = abc_2169_auto_rtlil_cc_2739_MuxGate_1850

xsubckt_799_dff_x1 1 0 881 356 62 dff_x1
xsubckt_798_dff_x1 1 0 882 356 60 dff_x1
xsubckt_797_dff_x1 1 0 883 356 58 dff_x1
xsubckt_796_dff_x1 1 0 884 356 55 dff_x1
xsubckt_795_dff_x1 1 0 885 356 53 dff_x1
xsubckt_172_or3_x1 1 0 971 592 593 594 or3_x1
xsubckt_322_and2_x1 1 0 479 254 684 and2_x1
xsubckt_533_and3_x1 1 0 791 642 64 355 and3_x1
xsubckt_564_or3_x1 1 0 873 768 769 770 or3_x1
xsubckt_619_nexor2_x0 1 0 638 658 858 nexor2_x0
xsubckt_649_nexor2_x0 1 0 712 668 845 nexor2_x0
xsubckt_243_and3_x1 1 0 538 641 7 355 and3_x1
xsubckt_198_and2_x1 1 0 572 346 684 and2_x1
xsubckt_176_or3_x1 1 0 970 589 590 591 or3_x1
xsubckt_79_xor2_x0 1 0 186 84 83 xor2_x0
xsubckt_92_nor4_x0 1 0 656 156 157 158 159 nor4_x0
xsubckt_529_and3_x1 1 0 794 641 86 355 and3_x1
xsubckt_568_or3_x1 1 0 872 765 766 767 or3_x1
xsubckt_594_and2_x1 1 0 745 270 684 and2_x1
xsubckt_318_and2_x1 1 0 482 253 684 and2_x1
xsubckt_441_and3_x1 1 0 390 642 14 355 and3_x1
xsubckt_688_nand3_x0 1 0 686 688 712 141 nand3_x0
xsubckt_679_nexor2_x0 1 0 693 679 834 nexor2_x0
xsubckt_648_and4_x1 1 0 711 714 726 157 158 and4_x1
xsubckt_239_and3_x1 1 0 541 641 6 355 and3_x1
xsubckt_226_and2_x1 1 0 551 228 684 and2_x1
xsubckt_103_nor4_x0 1 0 645 153 154 143 142 nor4_x0
xsubckt_151_and3_x1 1 0 607 641 108 355 and3_x1
xsubckt_359_nand3_x0 1 0 451 642 197 355 nand3_x0
xsubckt_437_and3_x1 1 0 393 642 11 355 and3_x1
xsubckt_312_or3_x1 1 0 936 487 488 489 or3_x1
xsubckt_316_or3_x1 1 0 935 484 485 486 or3_x1
xsubckt_54_xor2_x0 1 0 225 29 28 xor2_x0
xsubckt_108_and3_x1 1 0 640 642 199 355 and3_x1
xsubckt_134_and2_x1 1 0 620 328 684 and2_x1
xsubckt_147_and3_x1 1 0 610 641 107 355 and3_x1
xsubckt_345_and3_x1 1 0 462 642 194 355 and3_x1
xsubckt_498_and2_x1 1 0 817 302 684 and2_x1
xsubckt_543_and3_x1 1 0 783 641 90 355 and3_x1
xsubckt_276_or3_x1 1 0 945 514 515 516 or3_x1
xsubckt_272_or3_x1 1 0 946 517 518 519 or3_x1
xsubckt_89_xor2_x0 1 0 196 67 56 xor2_x0
xsubckt_530_and2_x1 1 0 793 311 684 and2_x1
xsubckt_253_and3_x1 1 0 531 642 171 355 and3_x1
xsubckt_451_and3_x1 1 0 382 642 18 355 and3_x1
xsubckt_526_and2_x1 1 0 796 310 684 and2_x1
xsubckt_539_and3_x1 1 0 786 641 88 355 and3_x1
xsubckt_249_and3_x1 1 0 534 642 170 355 and3_x1
xsubckt_98_nor4_x0 1 0 650 148 147 146 145 nor4_x0
xsubckt_671_and2_x1 1 0 696 697 699 and2_x1
xsubckt_161_and3_x1 1 0 600 642 212 355 and3_x1
xsubckt_434_and2_x1 1 0 395 285 684 and2_x1
xsubckt_447_and3_x1 1 0 385 641 63 355 and3_x1
xsubckt_613_nand3_x0 1 0 731 641 128 355 nand3_x0
xsubckt_64_xor2_x0 1 0 171 51 50 xor2_x0
xsubckt_94_and2_x1 1 0 654 161 162 and2_x1
xsubckt_157_and3_x1 1 0 603 642 211 355 and3_x1
xsubckt_412_or3_x1 1 0 911 412 413 414 or3_x1
xsubckt_416_or3_x1 1 0 910 409 410 411 or3_x1
xsubckt_342_and2_x1 1 0 464 260 684 and2_x1
xsubckt_355_and3_x1 1 0 454 641 38 355 and3_x1
xsubckt_372_or3_x1 1 0 921 442 443 444 or3_x1
xsubckt_553_and3_x1 1 0 776 642 75 355 and3_x1
xsubckt_628_and2_x1 1 0 723 724 725 and2_x1
xsubckt_263_and3_x1 1 0 523 641 13 355 and3_x1
xsubckt_107_or21nand_x0 1 0 641 643 646 659 or21nand_x0
xsubckt_376_or3_x1 1 0 920 439 440 441 or3_x1
xsubckt_549_and3_x1 1 0 779 642 73 355 and3_x1
xsubckt_250_and2_x1 1 0 533 234 684 and2_x1
xsubckt_338_and2_x1 1 0 467 258 684 and2_x1
xsubckt_461_and3_x1 1 0 375 642 25 355 and3_x1
xsubckt_633_and4_x1 1 0 720 724 725 134 133 and4_x1
xsubckt_742_dff_x1 1 0 938 356 183 dff_x1
xsubckt_741_dff_x1 1 0 939 356 182 dff_x1
xsubckt_740_dff_x1 1 0 940 356 181 dff_x1
xsubckt_259_and3_x1 1 0 526 641 11 355 and3_x1
xsubckt_246_and2_x1 1 0 536 233 684 and2_x1
xsubckt_171_and3_x1 1 0 592 641 113 355 and3_x1
xsubckt_457_and3_x1 1 0 378 642 22 355 and3_x1
xsubckt_748_dff_x1 1 0 932 356 189 dff_x1
xsubckt_747_dff_x1 1 0 933 356 188 dff_x1
xsubckt_746_dff_x1 1 0 934 356 187 dff_x1
xsubckt_745_dff_x1 1 0 935 356 186 dff_x1
xsubckt_744_dff_x1 1 0 936 356 185 dff_x1
xsubckt_743_dff_x1 1 0 937 356 184 dff_x1
xsubckt_120_or3_x1 1 0 984 631 632 633 or3_x1
xsubckt_512_or3_x1 1 0 886 807 808 809 or3_x1
xsubckt_749_dff_x1 1 0 931 356 190 dff_x1
xsubckt_677_and2_x1 1 0 693 694 699 and2_x1
xsubckt_167_and3_x1 1 0 595 641 112 355 and3_x1
xsubckt_74_xor2_x0 1 0 181 73 72 xor2_x0
xsubckt_35_xor2_x0 1 0 206 113 112 xor2_x0
xsubckt_124_or3_x1 1 0 983 628 629 630 or3_x1
xsubckt_154_and2_x1 1 0 605 334 684 and2_x1
xsubckt_365_and3_x1 1 0 447 642 98 355 and3_x1
xsubckt_516_or3_x1 1 0 885 804 805 806 or3_x1
xsubckt_563_and3_x1 1 0 768 642 80 355 and3_x1
xsubckt_0_inv_x0 1 0 355 684 inv_x0
xsubckt_1_inv_x0 1 0 142 683 inv_x0
xsubckt_2_inv_x0 1 0 141 682 inv_x0
xsubckt_3_inv_x0 1 0 138 681 inv_x0
xsubckt_4_inv_x0 1 0 143 680 inv_x0
xsubckt_128_or3_x1 1 0 982 625 626 627 or3_x1
xsubckt_472_or3_x1 1 0 896 367 368 369 or3_x1
xsubckt_476_or3_x1 1 0 895 364 365 366 or3_x1
xsubckt_550_and2_x1 1 0 778 317 684 and2_x1
xsubckt_273_and3_x1 1 0 516 641 16 355 and3_x1
xsubckt_5_inv_x0 1 0 145 679 inv_x0
xsubckt_6_inv_x0 1 0 147 678 inv_x0
xsubckt_7_inv_x0 1 0 148 677 inv_x0
xsubckt_8_inv_x0 1 0 151 676 inv_x0
xsubckt_9_inv_x0 1 0 149 675 inv_x0
xsubckt_471_and3_x1 1 0 367 641 70 355 and3_x1
xsubckt_546_and2_x1 1 0 781 316 684 and2_x1
xsubckt_559_and3_x1 1 0 771 641 94 355 and3_x1
xsubckt_844_dff_x1 1 0 837 356 148 dff_x1
xsubckt_843_dff_x1 1 0 838 356 149 dff_x1
xsubckt_842_dff_x1 1 0 839 356 151 dff_x1
xsubckt_841_dff_x1 1 0 840 356 152 dff_x1
xsubckt_840_dff_x1 1 0 841 356 153 dff_x1
xsubckt_269_and3_x1 1 0 519 642 175 355 and3_x1
xsubckt_181_and3_x1 1 0 585 642 217 355 and3_x1
xsubckt_454_and2_x1 1 0 380 290 684 and2_x1
xsubckt_467_and3_x1 1 0 370 641 69 355 and3_x1
xsubckt_615_nand3_x0 1 0 729 642 89 355 nand3_x0
xsubckt_630_nor2_x0 1 0 853 722 723 nor2_x0
xsubckt_639_and4_x1 1 0 717 720 160 131 132 and4_x1
xsubckt_849_dff_x1 1 0 832 356 143 dff_x1
xsubckt_848_dff_x1 1 0 833 356 144 dff_x1
xsubckt_847_dff_x1 1 0 834 356 145 dff_x1
xsubckt_846_dff_x1 1 0 835 356 146 dff_x1
xsubckt_845_dff_x1 1 0 836 356 147 dff_x1
xsubckt_301_and3_x1 1 0 495 642 183 355 and3_x1
xsubckt_224_or3_x1 1 0 958 553 554 555 or3_x1
xsubckt_220_or3_x1 1 0 959 556 557 558 or3_x1
xsubckt_177_and3_x1 1 0 588 642 216 355 and3_x1
xsubckt_612_or3_x1 1 0 861 732 733 734 or3_x1
xsubckt_687_and2_x1 1 0 687 688 712 and2_x1
xsubckt_228_or3_x1 1 0 957 550 551 552 or3_x1
xsubckt_180_or3_x1 1 0 969 586 587 588 or3_x1
xsubckt_45_xor2_x0 1 0 216 9 8 xor2_x0
xsubckt_84_xor2_x0 1 0 191 95 94 xor2_x0
xsubckt_362_and2_x1 1 0 449 265 684 and2_x1
xsubckt_375_and3_x1 1 0 439 641 43 355 and3_x1
xsubckt_486_nand2_x0 1 0 826 299 684 nand2_x0
xsubckt_572_or3_x1 1 0 871 762 763 764 or3_x1
xsubckt_573_and3_x1 1 0 761 642 86 355 and3_x1
xsubckt_184_or3_x1 1 0 968 583 584 585 or3_x1
xsubckt_93_nor4_x0 1 0 655 160 131 133 132 nor4_x0
xsubckt_569_and3_x1 1 0 764 642 84 355 and3_x1
xsubckt_576_or3_x1 1 0 870 759 760 761 or3_x1
xsubckt_283_and3_x1 1 0 508 641 18 355 and3_x1
xsubckt_270_and2_x1 1 0 518 240 684 and2_x1
xsubckt_230_nand2_x0 1 0 548 229 684 nand2_x0
xsubckt_205_and3_x1 1 0 567 642 223 355 and3_x1
xsubckt_188_or3_x1 1 0 967 580 581 582 or3_x1
xsubckt_403_and3_x1 1 0 418 641 51 355 and3_x1
xsubckt_481_and3_x1 1 0 360 642 36 355 and3_x1
xsubckt_279_and3_x1 1 0 511 641 17 355 and3_x1
xsubckt_191_and3_x1 1 0 577 641 119 355 and3_x1
xsubckt_14_inv_x0 1 0 159 670 inv_x0
xsubckt_13_inv_x0 1 0 153 671 inv_x0
xsubckt_12_inv_x0 1 0 152 672 inv_x0
xsubckt_11_inv_x0 1 0 155 673 inv_x0
xsubckt_10_inv_x0 1 0 154 674 inv_x0
xsubckt_477_and3_x1 1 0 363 642 33 355 and3_x1
xsubckt_601_and3_x1 1 0 740 642 23 355 and3_x1
xsubckt_320_or3_x1 1 0 934 481 482 483 or3_x1
xsubckt_311_and3_x1 1 0 487 641 26 355 and3_x1
xsubckt_266_and2_x1 1 0 521 239 684 and2_x1
xsubckt_19_inv_x0 1 0 133 665 inv_x0
xsubckt_18_inv_x0 1 0 132 666 inv_x0
xsubckt_17_inv_x0 1 0 156 667 inv_x0
xsubckt_16_inv_x0 1 0 157 668 inv_x0
xsubckt_15_inv_x0 1 0 158 669 inv_x0
xsubckt_113_and3_x1 1 0 636 641 98 355 and3_x1
xsubckt_616_nand3_x0 1 0 860 729 730 731 nand3_x0
xsubckt_187_and3_x1 1 0 580 641 118 355 and3_x1
xsubckt_174_and2_x1 1 0 590 339 684 and2_x1
xsubckt_55_xor2_x0 1 0 226 31 30 xor2_x0
xsubckt_324_or3_x1 1 0 933 478 479 480 or3_x1
xsubckt_350_nand2_x0 1 0 458 262 684 nand2_x0
xsubckt_385_and3_x1 1 0 432 642 109 355 and3_x1
xsubckt_583_and3_x1 1 0 753 641 12 355 and3_x1
xsubckt_307_and3_x1 1 0 490 642 184 355 and3_x1
xsubckt_280_or3_x1 1 0 944 511 512 513 or3_x1
xsubckt_328_or3_x1 1 0 932 475 476 477 or3_x1
xsubckt_505_and3_x1 1 0 812 642 49 355 and3_x1
xsubckt_570_and2_x1 1 0 763 330 684 and2_x1
xsubckt_663_and4_x1 1 0 703 153 155 154 151 and4_x1
xsubckt_293_and3_x1 1 0 501 642 181 355 and3_x1
xsubckt_288_or3_x1 1 0 942 505 506 507 or3_x1
xsubckt_284_or3_x1 1 0 943 508 509 510 or3_x1
xsubckt_491_and3_x1 1 0 822 642 40 355 and3_x1
xsubckt_579_and3_x1 1 0 756 642 88 355 and3_x1
xsubckt_215_and3_x1 1 0 559 641 125 355 and3_x1
xsubckt_202_and2_x1 1 0 569 347 684 and2_x1
xsubckt_101_and4_x1 1 0 647 648 650 651 656 and4_x1
xsubckt_413_and3_x1 1 0 411 642 124 355 and3_x1
xsubckt_566_and2_x1 1 0 766 321 684 and2_x1
xsubckt_611_and3_x1 1 0 732 641 89 355 and3_x1
xsubckt_624_and4_x1 1 0 725 653 137 139 355 and4_x1
xsubckt_646_and3_x1 1 0 712 714 726 158 and3_x1
xsubckt_289_and3_x1 1 0 504 642 180 355 and3_x1
xsubckt_99_nor4_x0 1 0 649 152 155 149 151 nor4_x0
xsubckt_474_and2_x1 1 0 365 296 684 and2_x1
xsubckt_654_nand4_x0 1 0 708 711 156 155 154 nand4_x0
xsubckt_30_xor2_x0 1 0 201 102 101 xor2_x0
xsubckt_110_and2_x1 1 0 638 641 355 and2_x1
xsubckt_123_and3_x1 1 0 628 641 100 355 and3_x1
xsubckt_321_and3_x1 1 0 480 642 188 355 and3_x1
xsubckt_409_and3_x1 1 0 414 642 122 355 and3_x1
xsubckt_420_or3_x1 1 0 909 406 407 408 or3_x1
xsubckt_607_and3_x1 1 0 735 641 78 355 and3_x1
xsubckt_621_nexor2_x0 1 0 728 161 857 nexor2_x0
xsubckt_668_and2_x1 1 0 698 699 149 and2_x1
xsubckt_660_nexor2_x0 1 0 706 672 840 nexor2_x0
xsubckt_317_and3_x1 1 0 483 642 187 355 and3_x1
xsubckt_197_and3_x1 1 0 573 642 221 355 and3_x1
xsubckt_65_xor2_x0 1 0 172 53 52 xor2_x0
xsubckt_119_and3_x1 1 0 631 641 99 355 and3_x1
xsubckt_380_or3_x1 1 0 919 436 437 438 or3_x1
xsubckt_382_and2_x1 1 0 434 271 684 and2_x1
xsubckt_395_and3_x1 1 0 424 641 49 355 and3_x1
xsubckt_424_or3_x1 1 0 908 403 404 405 or3_x1
xsubckt_428_or3_x1 1 0 907 400 401 402 or3_x1
xsubckt_593_and3_x1 1 0 746 642 105 355 and3_x1
xsubckt_651_nexor2_x0 1 0 711 667 844 nexor2_x0
xsubckt_384_or3_x1 1 0 918 433 434 435 or3_x1
xsubckt_502_and2_x1 1 0 814 304 684 and2_x1
xsubckt_515_and3_x1 1 0 804 641 82 355 and3_x1
xsubckt_290_and2_x1 1 0 503 245 684 and2_x1
xsubckt_225_and3_x1 1 0 552 642 164 355 and3_x1
xsubckt_378_and2_x1 1 0 437 269 684 and2_x1
xsubckt_388_or3_x1 1 0 917 430 431 432 or3_x1
xsubckt_589_and3_x1 1 0 749 642 95 355 and3_x1
xsubckt_681_nexor2_x0 1 0 692 144 833 nexor2_x0
xsubckt_299_and3_x1 1 0 496 641 22 355 and3_x1
xsubckt_410_and2_x1 1 0 413 278 684 and2_x1
xsubckt_423_and3_x1 1 0 403 641 57 355 and3_x1
xsubckt_497_and3_x1 1 0 818 642 44 355 and3_x1
xsubckt_755_dff_x1 1 0 925 356 196 dff_x1
xsubckt_754_dff_x1 1 0 926 356 195 dff_x1
xsubckt_753_dff_x1 1 0 927 356 194 dff_x1
xsubckt_752_dff_x1 1 0 928 356 193 dff_x1
xsubckt_751_dff_x1 1 0 929 356 192 dff_x1
xsubckt_750_dff_x1 1 0 930 356 191 dff_x1
xsubckt_682_and2_x1 1 0 690 691 143 and2_x1
xsubckt_672_nexor2_x0 1 0 698 677 837 nexor2_x0
xsubckt_286_and2_x1 1 0 506 244 684 and2_x1
xsubckt_40_xor2_x0 1 0 211 124 123 xor2_x0
xsubckt_133_and3_x1 1 0 621 642 205 355 and3_x1
xsubckt_331_and3_x1 1 0 472 641 31 355 and3_x1
xsubckt_419_and3_x1 1 0 406 641 55 355 and3_x1
xsubckt_520_or3_x1 1 0 884 801 802 803 or3_x1
xsubckt_618_nand3_x0 1 0 728 641 162 355 nand3_x0
xsubckt_759_dff_x1 1 0 921 356 100 dff_x1
xsubckt_758_dff_x1 1 0 922 356 98 dff_x1
xsubckt_757_dff_x1 1 0 923 356 198 dff_x1
xsubckt_756_dff_x1 1 0 924 356 197 dff_x1
xsubckt_75_xor2_x0 1 0 182 75 74 xor2_x0
xsubckt_132_or3_x1 1 0 981 622 623 624 or3_x1
xsubckt_406_and2_x1 1 0 416 277 684 and2_x1
xsubckt_524_or3_x1 1 0 883 798 799 800 or3_x1
xsubckt_645_nexor2_x0 1 0 717 670 847 nexor2_x0
xsubckt_314_and2_x1 1 0 485 252 684 and2_x1
xsubckt_194_and2_x1 1 0 575 345 684 and2_x1
xsubckt_36_xor2_x0 1 0 207 115 114 xor2_x0
xsubckt_129_and3_x1 1 0 624 642 204 355 and3_x1
xsubckt_136_or3_x1 1 0 980 619 620 621 or3_x1
xsubckt_327_and3_x1 1 0 475 641 30 355 and3_x1
xsubckt_480_or3_x1 1 0 894 361 362 363 or3_x1
xsubckt_525_and3_x1 1 0 797 642 60 355 and3_x1
xsubckt_528_or3_x1 1 0 882 795 796 797 or3_x1
xsubckt_590_and2_x1 1 0 748 259 684 and2_x1
xsubckt_636_nexor2_x0 1 0 720 666 850 nexor2_x0
xsubckt_684_nexor2_x0 1 0 690 683 831 nexor2_x0
xsubckt_675_nexor2_x0 1 0 695 146 835 nexor2_x0
xsubckt_360_nand3_x0 1 0 924 451 452 453 nand3_x0
xsubckt_484_or3_x1 1 0 893 358 359 360 or3_x1
xsubckt_599_and3_x1 1 0 741 641 56 355 and3_x1
xsubckt_235_and3_x1 1 0 544 642 166 355 and3_x1
xsubckt_229_nand3_x0 1 0 549 641 4 355 nand3_x0
xsubckt_222_and2_x1 1 0 554 227 684 and2_x1
xsubckt_433_and3_x1 1 0 396 642 9 355 and3_x1
xsubckt_586_and2_x1 1 0 751 248 684 and2_x1
xsubckt_631_and3_x1 1 0 721 724 725 134 and3_x1
xsubckt_851_dff_x1 1 0 830 356 141 dff_x1
xsubckt_850_dff_x1 1 0 831 356 142 dff_x1
xsubckt_658_and21nor_x0 1 0 841 671 708 706 and21nor_x0
xsubckt_494_and2_x1 1 0 820 301 684 and2_x1
xsubckt_854_dff_x1 1 0 827 356 137 dff_x1
xsubckt_853_dff_x1 1 0 828 356 138 dff_x1
xsubckt_852_dff_x1 1 0 829 356 140 dff_x1
xsubckt_218_and2_x1 1 0 557 351 684 and2_x1
xsubckt_50_xor2_x0 1 0 221 20 19 xor2_x0
xsubckt_130_and2_x1 1 0 623 327 684 and2_x1
xsubckt_143_and3_x1 1 0 613 641 106 355 and3_x1
xsubckt_341_and3_x1 1 0 465 642 193 355 and3_x1
xsubckt_429_and3_x1 1 0 399 642 7 355 and3_x1
xsubckt_236_or3_x1 1 0 955 544 545 546 or3_x1
xsubckt_46_xor2_x0 1 0 217 11 10 xor2_x0
xsubckt_85_xor2_x0 1 0 192 105 96 xor2_x0
xsubckt_139_and3_x1 1 0 616 641 104 355 and3_x1
xsubckt_349_nand3_x0 1 0 459 641 37 355 nand3_x0
xsubckt_678_nand3_x0 1 0 692 694 699 145 nand3_x0
xsubckt_669_nexor2_x0 1 0 699 675 838 nexor2_x0
xsubckt_192_or3_x1 1 0 966 577 578 579 or3_x1
xsubckt_126_and2_x1 1 0 626 326 684 and2_x1
xsubckt_337_and3_x1 1 0 468 641 33 355 and3_x1
xsubckt_522_and2_x1 1 0 799 309 684 and2_x1
xsubckt_535_and3_x1 1 0 789 641 87 355 and3_x1
xsubckt_580_or3_x1 1 0 869 756 757 758 or3_x1
xsubckt_584_or3_x1 1 0 868 753 754 755 or3_x1
xsubckt_245_and3_x1 1 0 537 642 169 355 and3_x1
xsubckt_196_or3_x1 1 0 965 574 575 576 or3_x1
xsubckt_398_and2_x1 1 0 422 275 684 and2_x1
xsubckt_588_or3_x1 1 0 867 750 751 752 or3_x1
xsubckt_641_and3_x1 1 0 716 139 134 160 and3_x1
xsubckt_20_inv_x0 1 0 131 664 inv_x0
xsubckt_21_inv_x0 1 0 160 663 inv_x0
xsubckt_430_and2_x1 1 0 398 284 684 and2_x1
xsubckt_443_and3_x1 1 0 388 641 62 355 and3_x1
xsubckt_518_and2_x1 1 0 802 308 684 and2_x1
xsubckt_60_xor2_x0 1 0 167 42 41 xor2_x0
xsubckt_22_inv_x0 1 0 134 662 inv_x0
xsubckt_23_inv_x0 1 0 136 661 inv_x0
xsubckt_24_inv_x0 1 0 139 660 inv_x0
xsubckt_25_inv_x0 1 0 137 659 inv_x0
xsubckt_26_inv_x0 1 0 162 658 inv_x0
xsubckt_153_and3_x1 1 0 606 642 210 355 and3_x1
xsubckt_439_and3_x1 1 0 391 641 61 355 and3_x1
xsubckt_637_and3_x1 1 0 718 720 131 132 and3_x1
xsubckt_27_inv_x0 1 0 150 657 inv_x0
xsubckt_332_or3_x1 1 0 931 472 473 474 or3_x1
xsubckt_426_and2_x1 1 0 401 283 684 and2_x1
xsubckt_659_and2_x1 1 0 705 706 152 and2_x1
xsubckt_56_xor2_x0 1 0 163 33 32 xor2_x0
xsubckt_149_and3_x1 1 0 609 642 209 355 and3_x1
xsubckt_336_or3_x1 1 0 930 469 470 471 or3_x1
xsubckt_347_and3_x1 1 0 460 641 36 355 and3_x1
xsubckt_545_and3_x1 1 0 782 642 71 355 and3_x1
xsubckt_296_or3_x1 1 0 940 499 500 501 or3_x1
xsubckt_292_or3_x1 1 0 941 502 503 504 or3_x1
xsubckt_334_and2_x1 1 0 470 257 684 and2_x1
xsubckt_702_dff_x1 1 0 978 356 207 dff_x1
xsubckt_701_dff_x1 1 0 979 356 206 dff_x1
xsubckt_700_dff_x1 1 0 980 356 205 dff_x1
xsubckt_255_and3_x1 1 0 529 641 10 355 and3_x1
xsubckt_242_and2_x1 1 0 539 232 684 and2_x1
xsubckt_453_and3_x1 1 0 381 642 20 355 and3_x1
xsubckt_708_dff_x1 1 0 972 356 213 dff_x1
xsubckt_707_dff_x1 1 0 973 356 212 dff_x1
xsubckt_706_dff_x1 1 0 974 356 211 dff_x1
xsubckt_705_dff_x1 1 0 975 356 210 dff_x1
xsubckt_704_dff_x1 1 0 976 356 209 dff_x1
xsubckt_703_dff_x1 1 0 977 356 208 dff_x1
xsubckt_709_dff_x1 1 0 971 356 214 dff_x1
xsubckt_238_and2_x1 1 0 542 231 684 and2_x1
xsubckt_163_and3_x1 1 0 598 641 111 355 and3_x1
xsubckt_70_xor2_x0 1 0 177 64 63 xor2_x0
xsubckt_31_xor2_x0 1 0 202 104 103 xor2_x0
xsubckt_102_nand4_x0 1 0 646 648 650 651 656 nand4_x0
xsubckt_150_and2_x1 1 0 608 333 684 and2_x1
xsubckt_361_and3_x1 1 0 450 641 40 355 and3_x1
xsubckt_449_and3_x1 1 0 384 641 64 355 and3_x1
xsubckt_66_xor2_x0 1 0 173 55 54 xor2_x0
xsubckt_159_and3_x1 1 0 601 641 110 355 and3_x1
xsubckt_432_or3_x1 1 0 906 397 398 399 or3_x1
xsubckt_436_or3_x1 1 0 905 394 395 396 or3_x1
xsubckt_146_and2_x1 1 0 611 332 684 and2_x1
xsubckt_392_or3_x1 1 0 916 427 428 429 or3_x1
xsubckt_542_and2_x1 1 0 784 315 684 and2_x1
xsubckt_555_and3_x1 1 0 774 641 93 355 and3_x1
xsubckt_265_and3_x1 1 0 522 642 174 355 and3_x1
xsubckt_396_or3_x1 1 0 915 424 425 426 or3_x1
xsubckt_805_dff_x1 1 0 875 356 75 dff_x1
xsubckt_804_dff_x1 1 0 876 356 73 dff_x1
xsubckt_803_dff_x1 1 0 877 356 71 dff_x1
xsubckt_802_dff_x1 1 0 878 356 69 dff_x1
xsubckt_801_dff_x1 1 0 879 356 66 dff_x1
xsubckt_800_dff_x1 1 0 880 356 64 dff_x1
xsubckt_450_and2_x1 1 0 383 289 684 and2_x1
xsubckt_463_and3_x1 1 0 373 641 68 355 and3_x1
xsubckt_538_and2_x1 1 0 787 313 684 and2_x1
xsubckt_622_and3_x1 1 0 726 653 137 355 and3_x1
xsubckt_809_dff_x1 1 0 871 356 84 dff_x1
xsubckt_808_dff_x1 1 0 872 356 82 dff_x1
xsubckt_807_dff_x1 1 0 873 356 80 dff_x1
xsubckt_806_dff_x1 1 0 874 356 77 dff_x1
xsubckt_762_dff_x1 1 0 918 356 107 dff_x1
xsubckt_761_dff_x1 1 0 919 356 104 dff_x1
xsubckt_760_dff_x1 1 0 920 356 102 dff_x1
xsubckt_173_and3_x1 1 0 591 642 215 355 and3_x1
xsubckt_80_xor2_x0 1 0 187 86 85 xor2_x0
xsubckt_459_and3_x1 1 0 376 641 66 355 and3_x1
xsubckt_767_dff_x1 1 0 913 356 118 dff_x1
xsubckt_766_dff_x1 1 0 914 356 115 dff_x1
xsubckt_765_dff_x1 1 0 915 356 113 dff_x1
xsubckt_764_dff_x1 1 0 916 356 111 dff_x1
xsubckt_763_dff_x1 1 0 917 356 109 dff_x1
xsubckt_644_and2_x1 1 0 713 714 726 and2_x1
xsubckt_41_xor2_x0 1 0 212 126 125 xor2_x0
xsubckt_140_or3_x1 1 0 979 616 617 618 or3_x1
xsubckt_371_and3_x1 1 0 442 641 42 355 and3_x1
xsubckt_446_and2_x1 1 0 386 288 684 and2_x1
xsubckt_532_or3_x1 1 0 881 792 793 794 or3_x1
xsubckt_769_dff_x1 1 0 911 356 122 dff_x1
xsubckt_768_dff_x1 1 0 912 356 120 dff_x1
xsubckt_169_and3_x1 1 0 594 642 214 355 and3_x1
xsubckt_76_xor2_x0 1 0 183 77 76 xor2_x0
xsubckt_37_xor2_x0 1 0 208 118 117 xor2_x0
xsubckt_144_or3_x1 1 0 978 613 614 615 or3_x1
xsubckt_367_and3_x1 1 0 445 641 41 355 and3_x1
xsubckt_536_or3_x1 1 0 880 789 790 791 or3_x1
xsubckt_565_and3_x1 1 0 767 642 82 355 and3_x1
xsubckt_201_and3_x1 1 0 570 642 222 355 and3_x1
xsubckt_148_or3_x1 1 0 977 610 611 612 or3_x1
xsubckt_354_and2_x1 1 0 455 263 684 and2_x1
xsubckt_492_or3_x1 1 0 891 822 823 824 or3_x1
xsubckt_275_and3_x1 1 0 514 642 176 355 and3_x1
xsubckt_100_nor4_x0 1 0 648 144 138 140 141 nor4_x0
xsubckt_473_and3_x1 1 0 366 642 31 355 and3_x1
xsubckt_496_or3_x1 1 0 890 819 820 821 or3_x1
xsubckt_262_and2_x1 1 0 524 238 684 and2_x1
xsubckt_258_and2_x1 1 0 527 236 684 and2_x1
xsubckt_183_and3_x1 1 0 583 641 117 355 and3_x1
xsubckt_170_and2_x1 1 0 593 338 684 and2_x1
xsubckt_51_xor2_x0 1 0 222 22 21 xor2_x0
xsubckt_90_xor2_x0 1 0 197 89 78 xor2_x0
xsubckt_381_and3_x1 1 0 435 642 107 355 and3_x1
xsubckt_469_and3_x1 1 0 369 642 29 355 and3_x1
xsubckt_303_and3_x1 1 0 493 641 24 355 and3_x1
xsubckt_240_or3_x1 1 0 954 541 542 543 or3_x1
xsubckt_179_and3_x1 1 0 586 641 115 355 and3_x1
xsubckt_501_and3_x1 1 0 815 642 47 355 and3_x1
xsubckt_248_or3_x1 1 0 952 535 536 537 or3_x1
xsubckt_244_or3_x1 1 0 953 538 539 540 or3_x1
xsubckt_166_and2_x1 1 0 596 337 684 and2_x1
xsubckt_47_xor2_x0 1 0 218 14 13 xor2_x0
xsubckt_86_xor2_x0 1 0 193 127 116 xor2_x0
xsubckt_106_and21nor_x0 1 0 642 644 647 137 and21nor_x0
xsubckt_377_and3_x1 1 0 438 642 104 355 and3_x1
xsubckt_562_and2_x1 1 0 769 320 684 and2_x1
xsubckt_575_and3_x1 1 0 759 641 116 355 and3_x1
xsubckt_592_or3_x1 1 0 866 747 748 749 or3_x1
xsubckt_211_and3_x1 1 0 562 642 224 355 and3_x1
xsubckt_596_or3_x1 1 0 865 744 745 746 or3_x1
xsubckt_285_and3_x1 1 0 507 642 179 355 and3_x1
xsubckt_207_and3_x1 1 0 565 641 123 355 and3_x1
xsubckt_405_and3_x1 1 0 417 642 120 355 and3_x1
xsubckt_470_and2_x1 1 0 368 295 684 and2_x1
xsubckt_483_and3_x1 1 0 358 641 73 355 and3_x1
xsubckt_558_and2_x1 1 0 772 319 684 and2_x1
xsubckt_193_and3_x1 1 0 576 641 120 355 and3_x1
xsubckt_105_nand4_x0 1 0 643 645 649 652 655 nand4_x0
xsubckt_479_and3_x1 1 0 361 641 72 355 and3_x1
xsubckt_603_and3_x1 1 0 738 641 67 355 and3_x1
xsubckt_629_and21nor_x0 1 0 722 725 136 135 and21nor_x0
xsubckt_673_nand4_x0 1 0 695 699 149 148 147 nand4_x0
xsubckt_313_and3_x1 1 0 486 642 186 355 and3_x1
xsubckt_61_xor2_x0 1 0 168 44 43 xor2_x0
xsubckt_115_and3_x1 1 0 634 642 200 355 and3_x1
xsubckt_340_or3_x1 1 0 929 466 467 468 or3_x1
xsubckt_358_nand2_x0 1 0 452 264 684 nand2_x0
xsubckt_391_and3_x1 1 0 427 641 48 355 and3_x1
xsubckt_466_and2_x1 1 0 371 294 684 and2_x1
xsubckt_485_nand3_x0 1 0 357 641 74 355 nand3_x0
xsubckt_189_and3_x1 1 0 579 642 219 355 and3_x1
xsubckt_57_xor2_x0 1 0 164 36 35 xor2_x0
xsubckt_344_or3_x1 1 0 928 463 464 465 or3_x1
xsubckt_387_and3_x1 1 0 430 641 47 355 and3_x1
xsubckt_511_and3_x1 1 0 807 641 81 355 and3_x1
xsubckt_309_and3_x1 1 0 489 642 185 355 and3_x1
xsubckt_221_and3_x1 1 0 555 642 163 355 and3_x1
xsubckt_348_or3_x1 1 0 927 460 461 462 or3_x1
xsubckt_374_and2_x1 1 0 440 268 684 and2_x1
xsubckt_507_and3_x1 1 0 810 641 80 355 and3_x1
xsubckt_585_and3_x1 1 0 752 642 93 355 and3_x1
xsubckt_665_and4_x1 1 0 701 156 152 155 151 and4_x1
xsubckt_295_and3_x1 1 0 499 641 21 355 and3_x1
xsubckt_493_and3_x1 1 0 821 642 42 355 and3_x1
xsubckt_715_dff_x1 1 0 965 356 220 dff_x1
xsubckt_714_dff_x1 1 0 966 356 219 dff_x1
xsubckt_713_dff_x1 1 0 967 356 218 dff_x1
xsubckt_712_dff_x1 1 0 968 356 217 dff_x1
xsubckt_711_dff_x1 1 0 969 356 216 dff_x1
xsubckt_710_dff_x1 1 0 970 356 215 dff_x1
xsubckt_652_and3_x1 1 0 709 711 156 155 and3_x1
xsubckt_282_and2_x1 1 0 509 243 684 and2_x1
xsubckt_217_and3_x1 1 0 558 642 226 355 and3_x1
xsubckt_415_and3_x1 1 0 409 641 54 355 and3_x1
xsubckt_719_dff_x1 1 0 961 356 224 dff_x1
xsubckt_718_dff_x1 1 0 962 356 223 dff_x1
xsubckt_717_dff_x1 1 0 963 356 222 dff_x1
xsubckt_716_dff_x1 1 0 964 356 221 dff_x1
xsubckt_278_and2_x1 1 0 512 242 684 and2_x1
xsubckt_190_and2_x1 1 0 578 344 684 and2_x1
xsubckt_71_xor2_x0 1 0 178 66 65 xor2_x0
xsubckt_96_nand3_x0 1 0 652 161 150 162 nand3_x0
xsubckt_402_and2_x1 1 0 419 276 684 and2_x1
xsubckt_489_and3_x1 1 0 824 641 75 355 and3_x1
xsubckt_310_and2_x1 1 0 488 251 684 and2_x1
xsubckt_32_xor2_x0 1 0 203 107 106 xor2_x0
xsubckt_125_and3_x1 1 0 627 642 203 355 and3_x1
xsubckt_323_and3_x1 1 0 478 641 29 355 and3_x1
xsubckt_440_or3_x1 1 0 904 391 392 393 or3_x1
xsubckt_521_and3_x1 1 0 800 642 58 355 and3_x1
xsubckt_609_and3_x1 1 0 734 642 67 355 and3_x1
xsubckt_632_nexor2_x0 1 0 723 662 852 nexor2_x0
xsubckt_635_and2_x1 1 0 719 720 132 and2_x1
xsubckt_319_and3_x1 1 0 481 641 28 355 and3_x1
xsubckt_199_and3_x1 1 0 571 641 121 355 and3_x1
xsubckt_186_and2_x1 1 0 581 343 684 and2_x1
xsubckt_67_xor2_x0 1 0 174 58 57 xor2_x0
xsubckt_28_xor2_x0 1 0 199 98 97 xor2_x0
xsubckt_397_and3_x1 1 0 423 642 115 355 and3_x1
xsubckt_444_or3_x1 1 0 903 388 389 390 or3_x1
xsubckt_448_or3_x1 1 0 902 385 386 387 or3_x1
xsubckt_595_and3_x1 1 0 744 641 45 355 and3_x1
xsubckt_653_nexor2_x0 1 0 710 673 843 nexor2_x0
xsubckt_306_and2_x1 1 0 491 250 684 and2_x1
xsubckt_517_and3_x1 1 0 803 642 55 355 and3_x1
xsubckt_582_and2_x1 1 0 754 237 684 and2_x1
xsubckt_620_nand3_x0 1 0 727 641 654 355 nand3_x0
xsubckt_812_dff_x1 1 0 868 356 91 dff_x1
xsubckt_811_dff_x1 1 0 869 356 88 dff_x1
xsubckt_810_dff_x1 1 0 870 356 86 dff_x1
xsubckt_692_nexor2_x0 1 0 685 681 828 nexor2_x0
xsubckt_227_and3_x1 1 0 550 641 3 355 and3_x1
xsubckt_490_and2_x1 1 0 823 300 684 and2_x1
xsubckt_578_and2_x1 1 0 757 352 684 and2_x1
xsubckt_818_dff_x1 1 0 862 356 45 dff_x1
xsubckt_817_dff_x1 1 0 863 356 23 dff_x1
xsubckt_816_dff_x1 1 0 864 356 127 dff_x1
xsubckt_815_dff_x1 1 0 865 356 105 dff_x1
xsubckt_814_dff_x1 1 0 866 356 95 dff_x1
xsubckt_813_dff_x1 1 0 867 356 93 dff_x1
xsubckt_683_nexor2_x0 1 0 691 680 832 nexor2_x0
xsubckt_662_and3_x1 1 0 704 156 157 152 and3_x1
xsubckt_214_and2_x1 1 0 560 350 684 and2_x1
xsubckt_425_and3_x1 1 0 402 642 5 355 and3_x1
xsubckt_499_and3_x1 1 0 816 641 77 355 and3_x1
xsubckt_610_and2_x1 1 0 733 314 684 and2_x1
xsubckt_819_dff_x1 1 0 861 356 67 dff_x1
xsubckt_774_dff_x1 1 0 906 356 7 dff_x1
xsubckt_773_dff_x1 1 0 907 356 5 dff_x1
xsubckt_772_dff_x1 1 0 908 356 3 dff_x1
xsubckt_771_dff_x1 1 0 909 356 126 dff_x1
xsubckt_770_dff_x1 1 0 910 356 124 dff_x1
xsubckt_674_nexor2_x0 1 0 696 678 836 nexor2_x0
xsubckt_42_xor2_x0 1 0 213 3 2 xor2_x0
xsubckt_81_xor2_x0 1 0 188 88 87 xor2_x0
xsubckt_135_and3_x1 1 0 619 641 103 355 and3_x1
xsubckt_333_and3_x1 1 0 471 642 191 355 and3_x1
xsubckt_487_nand3_x0 1 0 825 642 38 355 nand3_x0
xsubckt_540_or3_x1 1 0 879 786 787 788 or3_x1
xsubckt_626_nexor2_x0 1 0 725 661 854 nexor2_x0
xsubckt_779_dff_x1 1 0 901 356 18 dff_x1
xsubckt_778_dff_x1 1 0 902 356 16 dff_x1
xsubckt_777_dff_x1 1 0 903 356 14 dff_x1
xsubckt_776_dff_x1 1 0 904 356 11 dff_x1
xsubckt_775_dff_x1 1 0 905 356 9 dff_x1
xsubckt_231_nand3_x0 1 0 547 642 165 355 nand3_x0
xsubckt_122_and2_x1 1 0 629 325 684 and2_x1
xsubckt_152_or3_x1 1 0 976 607 608 609 or3_x1
xsubckt_531_and3_x1 1 0 792 642 62 355 and3_x1
xsubckt_544_or3_x1 1 0 878 783 784 785 or3_x1
xsubckt_606_and2_x1 1 0 736 303 684 and2_x1
xsubckt_647_nexor2_x0 1 0 713 669 846 nexor2_x0
xsubckt_241_and3_x1 1 0 540 642 168 355 and3_x1
xsubckt_77_xor2_x0 1 0 184 80 79 xor2_x0
xsubckt_38_xor2_x0 1 0 209 120 119 xor2_x0
xsubckt_118_and2_x1 1 0 632 324 684 and2_x1
xsubckt_156_or3_x1 1 0 975 604 605 606 or3_x1
xsubckt_329_and3_x1 1 0 474 642 190 355 and3_x1
xsubckt_394_and2_x1 1 0 425 274 684 and2_x1
xsubckt_527_and3_x1 1 0 795 641 85 355 and3_x1
xsubckt_548_or3_x1 1 0 877 780 781 782 or3_x1
xsubckt_514_and2_x1 1 0 805 307 684 and2_x1
xsubckt_638_nexor2_x0 1 0 719 664 849 nexor2_x0
xsubckt_685_and4_x1 1 0 689 145 143 144 142 and4_x1
xsubckt_237_and3_x1 1 0 543 642 167 355 and3_x1
xsubckt_435_and3_x1 1 0 394 641 60 355 and3_x1
xsubckt_298_and2_x1 1 0 497 247 684 and2_x1
xsubckt_95_and3_x1 1 0 653 161 150 162 and3_x1
xsubckt_351_nand3_x0 1 0 457 642 195 355 nand3_x0
xsubckt_422_and2_x1 1 0 404 282 684 and2_x1
xsubckt_488_nand3_x0 1 0 892 825 826 357 nand3_x0
xsubckt_52_xor2_x0 1 0 223 25 24 xor2_x0
xsubckt_91_xor2_x0 1 0 198 129 128 xor2_x0
xsubckt_145_and3_x1 1 0 612 642 208 355 and3_x1
xsubckt_330_and2_x1 1 0 473 256 684 and2_x1
xsubckt_343_and3_x1 1 0 463 641 35 355 and3_x1
xsubckt_418_and2_x1 1 0 407 280 684 and2_x1
xsubckt_541_and3_x1 1 0 785 642 69 355 and3_x1
xsubckt_614_nand2_x0 1 0 730 353 684 nand2_x0
xsubckt_689_nexor2_x0 1 0 687 682 830 nexor2_x0
xsubckt_256_or3_x1 1 0 950 529 530 531 or3_x1
xsubckt_252_or3_x1 1 0 951 532 533 534 or3_x1
xsubckt_232_nand3_x0 1 0 956 547 548 549 nand3_x0
xsubckt_48_xor2_x0 1 0 219 16 15 xor2_x0
xsubckt_87_xor2_x0 1 0 194 23 12 xor2_x0
xsubckt_251_and3_x1 1 0 532 641 9 355 and3_x1
xsubckt_326_and2_x1 1 0 476 255 684 and2_x1
xsubckt_339_and3_x1 1 0 466 642 192 355 and3_x1
xsubckt_537_and3_x1 1 0 788 642 66 355 and3_x1
xsubckt_247_and3_x1 1 0 535 641 8 355 and3_x1
xsubckt_598_and2_x1 1 0 742 281 684 and2_x1
xsubckt_643_and3_x1 1 0 714 715 716 724 and3_x1
xsubckt_234_and2_x1 1 0 545 230 684 and2_x1
xsubckt_352_nand3_x0 1 0 926 457 458 459 nand3_x0
xsubckt_445_and3_x1 1 0 387 642 16 355 and3_x1
xsubckt_62_xor2_x0 1 0 169 47 46 xor2_x0
xsubckt_155_and3_x1 1 0 604 641 109 355 and3_x1
xsubckt_142_and2_x1 1 0 614 331 684 and2_x1
xsubckt_353_and3_x1 1 0 456 642 196 355 and3_x1
xsubckt_551_and3_x1 1 0 777 641 92 355 and3_x1
xsubckt_261_and3_x1 1 0 525 642 173 355 and3_x1
xsubckt_58_xor2_x0 1 0 165 38 37 xor2_x0
xsubckt_138_and2_x1 1 0 617 329 684 and2_x1
xsubckt_356_or3_x1 1 0 925 454 455 456 or3_x1
xsubckt_547_and3_x1 1 0 780 641 91 355 and3_x1
xsubckt_534_and2_x1 1 0 790 312 684 and2_x1
xsubckt_722_dff_x1 1 0 958 356 163 dff_x1
xsubckt_721_dff_x1 1 0 959 356 226 dff_x1
xsubckt_720_dff_x1 1 0 960 356 225 dff_x1
xsubckt_257_and3_x1 1 0 528 642 172 355 and3_x1
xsubckt_104_and4_x1 1 0 644 645 649 652 655 and4_x1
xsubckt_455_and3_x1 1 0 379 641 65 355 and3_x1
xsubckt_728_dff_x1 1 0 952 356 169 dff_x1
xsubckt_727_dff_x1 1 0 953 356 168 dff_x1
xsubckt_726_dff_x1 1 0 954 356 167 dff_x1
xsubckt_725_dff_x1 1 0 955 356 166 dff_x1
xsubckt_724_dff_x1 1 0 956 356 165 dff_x1
xsubckt_723_dff_x1 1 0 957 356 164 dff_x1
xsubckt_442_and2_x1 1 0 389 287 684 and2_x1
xsubckt_617_mux2_x1 1 0 354 129 355 859 mux2_x1
xsubckt_729_dff_x1 1 0 951 356 170 dff_x1
xsubckt_165_and3_x1 1 0 597 642 213 355 and3_x1
xsubckt_72_xor2_x0 1 0 179 69 68 xor2_x0
xsubckt_33_xor2_x0 1 0 204 109 108 xor2_x0
xsubckt_363_and3_x1 1 0 448 642 198 355 and3_x1
xsubckt_438_and2_x1 1 0 392 286 684 and2_x1
xsubckt_561_and3_x1 1 0 770 641 95 355 and3_x1
xsubckt_68_xor2_x0 1 0 175 60 59 xor2_x0
xsubckt_452_or3_x1 1 0 901 382 383 384 or3_x1
xsubckt_456_or3_x1 1 0 900 379 380 381 or3_x1
xsubckt_680_and4_x1 1 0 691 694 699 145 144 and4_x1
xsubckt_271_and3_x1 1 0 517 641 15 355 and3_x1
xsubckt_29_xor2_x0 1 0 200 100 99 xor2_x0
xsubckt_109_and2_x1 1 0 639 322 684 and2_x1
xsubckt_346_and2_x1 1 0 461 261 684 and2_x1
xsubckt_557_and3_x1 1 0 773 642 77 355 and3_x1
xsubckt_825_dff_x1 1 0 856 356 150 dff_x1
xsubckt_824_dff_x1 1 0 857 356 161 dff_x1
xsubckt_823_dff_x1 1 0 858 356 162 dff_x1
xsubckt_822_dff_x1 1 0 130 356 355 dff_x1
xsubckt_821_dff_x1 1 0 859 356 129 dff_x1
xsubckt_820_dff_x1 1 0 860 356 89 dff_x1
xsubckt_676_and4_x1 1 0 694 149 148 147 146 and4_x1
xsubckt_267_and3_x1 1 0 520 641 14 355 and3_x1
xsubckt_254_and2_x1 1 0 530 235 684 and2_x1
xsubckt_465_and3_x1 1 0 372 642 27 355 and3_x1
xsubckt_829_dff_x1 1 0 852 356 134 dff_x1
xsubckt_828_dff_x1 1 0 853 356 135 dff_x1
xsubckt_827_dff_x1 1 0 854 356 136 dff_x1
xsubckt_826_dff_x1 1 0 855 356 139 dff_x1
xsubckt_781_dff_x1 1 0 899 356 22 dff_x1
xsubckt_780_dff_x1 1 0 900 356 20 dff_x1
xsubckt_650_and2_x1 1 0 710 711 156 and2_x1
xsubckt_204_or3_x1 1 0 963 568 569 570 or3_x1
xsubckt_200_or3_x1 1 0 964 571 572 573 or3_x1
xsubckt_175_and3_x1 1 0 589 641 114 355 and3_x1
xsubckt_82_xor2_x0 1 0 189 91 90 xor2_x0
xsubckt_787_dff_x1 1 0 893 356 36 dff_x1
xsubckt_786_dff_x1 1 0 894 356 33 dff_x1
xsubckt_785_dff_x1 1 0 895 356 31 dff_x1
xsubckt_784_dff_x1 1 0 896 356 29 dff_x1
xsubckt_783_dff_x1 1 0 897 356 27 dff_x1
xsubckt_782_dff_x1 1 0 898 356 25 dff_x1
xsubckt_208_or3_x1 1 0 962 565 566 567 or3_x1
xsubckt_162_and2_x1 1 0 599 336 684 and2_x1
xsubckt_43_xor2_x0 1 0 214 5 4 xor2_x0
xsubckt_160_or3_x1 1 0 974 601 602 603 or3_x1
xsubckt_373_and3_x1 1 0 441 642 102 355 and3_x1
xsubckt_552_or3_x1 1 0 876 777 778 779 or3_x1
xsubckt_571_and3_x1 1 0 762 641 105 355 and3_x1
xcmpt_one_0 1 0 130 one_x1
xsubckt_789_dff_x1 1 0 891 356 40 dff_x1
xsubckt_788_dff_x1 1 0 892 356 38 dff_x1
xsubckt_164_or3_x1 1 0 973 598 599 600 or3_x1
xsubckt_78_xor2_x0 1 0 185 82 81 xor2_x0
xsubckt_39_xor2_x0 1 0 210 122 121 xor2_x0
xsubckt_158_and2_x1 1 0 602 335 684 and2_x1
xsubckt_369_and3_x1 1 0 444 642 100 355 and3_x1
xsubckt_556_or3_x1 1 0 875 774 775 776 or3_x1
xsubckt_567_and3_x1 1 0 765 641 96 355 and3_x1
xsubckt_690_and4_x1 1 0 685 688 712 140 141 and4_x1
xsubckt_281_and3_x1 1 0 510 642 178 355 and3_x1
xsubckt_203_and3_x1 1 0 568 641 122 355 and3_x1
xsubckt_168_or3_x1 1 0 972 595 596 597 or3_x1
xsubckt_401_and3_x1 1 0 420 642 118 355 and3_x1
xsubckt_554_and2_x1 1 0 775 318 684 and2_x1
xsubckt_686_and4_x1 1 0 688 689 694 701 702 and4_x1
xsubckt_277_and3_x1 1 0 513 642 177 355 and3_x1
xsubckt_475_and3_x1 1 0 364 641 71 355 and3_x1
xsubckt_300_or3_x1 1 0 939 496 497 498 or3_x1
xsubckt_111_and3_x1 1 0 637 641 97 355 and3_x1
xsubckt_462_and2_x1 1 0 374 293 684 and2_x1
xsubckt_304_or3_x1 1 0 938 493 494 495 or3_x1
xsubckt_185_and3_x1 1 0 582 642 218 355 and3_x1
xsubckt_53_xor2_x0 1 0 224 27 26 xor2_x0
xsubckt_383_and3_x1 1 0 433 641 46 355 and3_x1
xsubckt_458_and2_x1 1 0 377 291 684 and2_x1
xsubckt_581_and3_x1 1 0 755 642 91 355 and3_x1
xsubckt_656_and2_x1 1 0 707 153 154 and2_x1
xsubckt_308_or3_x1 1 0 937 490 491 492 or3_x1
xsubckt_305_and3_x1 1 0 492 641 25 355 and3_x1
xsubckt_260_or3_x1 1 0 949 526 527 528 or3_x1
xsubckt_370_and2_x1 1 0 443 267 684 and2_x1
xsubckt_503_and3_x1 1 0 813 641 79 355 and3_x1
xsubckt_291_and3_x1 1 0 502 641 20 355 and3_x1
xsubckt_268_or3_x1 1 0 947 520 521 522 or3_x1
xsubckt_264_or3_x1 1 0 948 523 524 525 or3_x1
xsubckt_49_xor2_x0 1 0 220 18 17 xor2_x0
xsubckt_88_xor2_x0 1 0 195 45 34 xor2_x0
xsubckt_366_and2_x1 1 0 446 266 684 and2_x1
xsubckt_379_and3_x1 1 0 436 641 44 355 and3_x1
xsubckt_577_and3_x1 1 0 758 641 127 355 and3_x1
xsubckt_213_and3_x1 1 0 561 642 225 355 and3_x1
xsubckt_411_and3_x1 1 0 412 641 53 355 and3_x1
xsubckt_657_and4_x1 1 0 706 707 711 156 155 and4_x1
xsubckt_287_and3_x1 1 0 505 641 19 355 and3_x1
xsubckt_274_and2_x1 1 0 515 241 684 and2_x1
xsubckt_209_and3_x1 1 0 564 641 124 355 and3_x1
xsubckt_97_nor4_x0 1 0 651 139 136 135 134 nor4_x0
xsubckt_670_and2_x1 1 0 697 149 148 and2_x1
xsubckt_195_and3_x1 1 0 574 642 220 355 and3_x1
xsubckt_121_and3_x1 1 0 630 642 202 355 and3_x1
xsubckt_400_or3_x1 1 0 914 421 422 423 or3_x1
xsubckt_407_and3_x1 1 0 415 641 52 355 and3_x1
xsubckt_605_and3_x1 1 0 737 642 45 355 and3_x1
xsubckt_666_and2_x1 1 0 700 703 704 and2_x1
xsubckt_315_and3_x1 1 0 484 641 27 355 and3_x1
xsubckt_182_and2_x1 1 0 584 342 684 and2_x1
xsubckt_63_xor2_x0 1 0 170 49 48 xor2_x0
xsubckt_117_and3_x1 1 0 633 642 201 355 and3_x1
xsubckt_393_and3_x1 1 0 426 642 113 355 and3_x1
xsubckt_404_or3_x1 1 0 913 418 419 420 or3_x1
xsubckt_408_or3_x1 1 0 912 415 416 417 or3_x1
xsubckt_591_and3_x1 1 0 747 641 34 355 and3_x1
xsubckt_627_and2_x1 1 0 724 136 135 and2_x1
xsubckt_302_and2_x1 1 0 494 249 684 and2_x1
xsubckt_59_xor2_x0 1 0 166 40 39 xor2_x0
xsubckt_364_or3_x1 1 0 923 448 449 450 or3_x1
xsubckt_389_and3_x1 1 0 429 642 111 355 and3_x1
xsubckt_513_and3_x1 1 0 806 642 53 355 and3_x1
xsubckt_223_and3_x1 1 0 553 641 2 355 and3_x1
xsubckt_178_and2_x1 1 0 587 340 684 and2_x1
xsubckt_368_or3_x1 1 0 922 445 446 447 or3_x1
xsubckt_509_and3_x1 1 0 809 642 51 355 and3_x1
xsubckt_574_and2_x1 1 0 760 341 684 and2_x1
xsubckt_587_and3_x1 1 0 750 641 23 355 and3_x1
xsubckt_640_nexor2_x0 1 0 718 663 848 nexor2_x0
xsubckt_297_and3_x1 1 0 498 642 182 355 and3_x1
xsubckt_210_and2_x1 1 0 563 349 684 and2_x1
xsubckt_421_and3_x1 1 0 405 642 3 355 and3_x1
xsubckt_495_and3_x1 1 0 819 641 76 355 and3_x1
xsubckt_623_and21nor_x0 1 0 856 657 727 726 and21nor_x0
xsubckt_735_dff_x1 1 0 945 356 176 dff_x1
xsubckt_734_dff_x1 1 0 946 356 175 dff_x1
xsubckt_733_dff_x1 1 0 947 356 174 dff_x1
xsubckt_732_dff_x1 1 0 948 356 173 dff_x1
xsubckt_731_dff_x1 1 0 949 356 172 dff_x1
xsubckt_730_dff_x1 1 0 950 356 171 dff_x1
xsubckt_693_and21nor_x0 1 0 827 138 685 659 and21nor_x0
xsubckt_667_and4_x1 1 0 699 700 714 726 158 and4_x1
xsubckt_661_nexor2_x0 1 0 705 676 839 nexor2_x0
xsubckt_219_and3_x1 1 0 556 641 126 355 and3_x1
xsubckt_206_and2_x1 1 0 566 348 684 and2_x1
xsubckt_131_and3_x1 1 0 622 641 102 355 and3_x1
xsubckt_357_nand3_x0 1 0 453 641 39 355 nand3_x0
xsubckt_417_and3_x1 1 0 408 642 126 355 and3_x1
xsubckt_482_and2_x1 1 0 359 298 684 and2_x1
xsubckt_500_or3_x1 1 0 889 816 817 818 or3_x1
xsubckt_739_dff_x1 1 0 941 356 180 dff_x1
xsubckt_738_dff_x1 1 0 942 356 179 dff_x1
xsubckt_737_dff_x1 1 0 943 356 178 dff_x1
xsubckt_736_dff_x1 1 0 944 356 177 dff_x1
xsubckt_73_xor2_x0 1 0 180 71 70 xor2_x0
xsubckt_112_or3_x1 1 0 986 637 639 640 or3_x1
xsubckt_478_and2_x1 1 0 362 297 684 and2_x1
xsubckt_504_or3_x1 1 0 888 813 814 815 or3_x1
xsubckt_602_and2_x1 1 0 739 292 684 and2_x1
xsubckt_697_dff_x1 1 0 983 356 202 dff_x1
xsubckt_696_dff_x1 1 0 984 356 201 dff_x1
xsubckt_695_dff_x1 1 0 985 356 200 dff_x1
xsubckt_694_dff_x1 1 0 986 356 199 dff_x1
xsubckt_691_nexor2_x0 1 0 686 140 829 nexor2_x0
xsubckt_34_xor2_x0 1 0 205 111 110 xor2_x0
xsubckt_114_and2_x1 1 0 635 323 684 and2_x1
xsubckt_116_or3_x1 1 0 985 634 635 636 or3_x1
xsubckt_127_and3_x1 1 0 625 641 101 355 and3_x1
xsubckt_325_and3_x1 1 0 477 642 189 355 and3_x1
xsubckt_390_and2_x1 1 0 428 273 684 and2_x1
xsubckt_460_or3_x1 1 0 899 376 377 378 or3_x1
xsubckt_508_or3_x1 1 0 887 810 811 812 or3_x1
xsubckt_523_and3_x1 1 0 798 641 84 355 and3_x1
xsubckt_634_nexor2_x0 1 0 721 665 851 nexor2_x0
xsubckt_699_dff_x1 1 0 981 356 204 dff_x1
xsubckt_698_dff_x1 1 0 982 356 203 dff_x1
xsubckt_69_xor2_x0 1 0 176 62 61 xor2_x0
xsubckt_386_and2_x1 1 0 431 272 684 and2_x1
xsubckt_399_and3_x1 1 0 421 641 50 355 and3_x1
xsubckt_464_or3_x1 1 0 898 373 374 375 or3_x1
xsubckt_468_or3_x1 1 0 897 370 371 372 or3_x1
xsubckt_510_and2_x1 1 0 808 306 684 and2_x1
xsubckt_597_and3_x1 1 0 743 642 127 355 and3_x1
xsubckt_625_nexor2_x0 1 0 726 660 855 nexor2_x0
xsubckt_642_and4_x1 1 0 715 131 133 132 159 and4_x1
xsubckt_233_and3_x1 1 0 546 641 5 355 and3_x1
xsubckt_431_and3_x1 1 0 397 641 59 355 and3_x1
xsubckt_506_and2_x1 1 0 811 305 684 and2_x1
xsubckt_519_and3_x1 1 0 801 641 83 355 and3_x1
xsubckt_832_dff_x1 1 0 849 356 131 dff_x1
xsubckt_831_dff_x1 1 0 850 356 132 dff_x1
xsubckt_830_dff_x1 1 0 851 356 133 dff_x1
xsubckt_655_nexor2_x0 1 0 709 674 842 nexor2_x0
xsubckt_294_and2_x1 1 0 500 246 684 and2_x1
xsubckt_837_dff_x1 1 0 844 356 156 dff_x1
xsubckt_836_dff_x1 1 0 845 356 157 dff_x1
xsubckt_835_dff_x1 1 0 846 356 158 dff_x1
xsubckt_834_dff_x1 1 0 847 356 159 dff_x1
xsubckt_833_dff_x1 1 0 848 356 160 dff_x1
xsubckt_664_and3_x1 1 0 702 157 153 154 and3_x1
xsubckt_141_and3_x1 1 0 615 642 207 355 and3_x1
xsubckt_414_and2_x1 1 0 410 279 684 and2_x1
xsubckt_427_and3_x1 1 0 400 641 58 355 and3_x1
xsubckt_600_or3_x1 1 0 864 741 742 743 or3_x1
xsubckt_839_dff_x1 1 0 842 356 154 dff_x1
xsubckt_838_dff_x1 1 0 843 356 155 dff_x1
xsubckt_794_dff_x1 1 0 886 356 51 dff_x1
xsubckt_793_dff_x1 1 0 887 356 49 dff_x1
xsubckt_792_dff_x1 1 0 888 356 47 dff_x1
xsubckt_791_dff_x1 1 0 889 356 44 dff_x1
xsubckt_790_dff_x1 1 0 890 356 42 dff_x1
xsubckt_216_or3_x1 1 0 960 559 560 561 or3_x1
xsubckt_212_or3_x1 1 0 961 562 563 564 or3_x1
xsubckt_44_xor2_x0 1 0 215 7 6 xor2_x0
xsubckt_83_xor2_x0 1 0 190 93 92 xor2_x0
xsubckt_137_and3_x1 1 0 618 642 206 355 and3_x1
xsubckt_335_and3_x1 1 0 469 641 32 355 and3_x1
xsubckt_560_or3_x1 1 0 874 771 772 773 or3_x1
xsubckt_604_or3_x1 1 0 863 738 739 740 or3_x1
xsubckt_608_or3_x1 1 0 862 735 736 737 or3_x1
.ends expmob2
