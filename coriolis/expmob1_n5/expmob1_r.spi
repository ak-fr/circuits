* Coriolis Structural SPICE Driver
* Generated on Apr 13, 2025, 01:41
* Cell/Subckt "expmob1_r".
*
* INTERF vss
* INTERF vdd
* INTERF outputs[9]
* INTERF outputs[8]
* INTERF outputs[7]
* INTERF outputs[6]
* INTERF outputs[5]
* INTERF outputs[4]
* INTERF outputs[31]
* INTERF outputs[30]
* INTERF outputs[3]
* INTERF outputs[29]
* INTERF outputs[28]
* INTERF outputs[27]
* INTERF outputs[26]
* INTERF outputs[25]
* INTERF outputs[24]
* INTERF outputs[23]
* INTERF outputs[22]
* INTERF outputs[21]
* INTERF outputs[20]
* INTERF outputs[2]
* INTERF outputs[19]
* INTERF outputs[18]
* INTERF outputs[17]
* INTERF outputs[16]
* INTERF outputs[15]
* INTERF outputs[14]
* INTERF outputs[13]
* INTERF outputs[12]
* INTERF outputs[11]
* INTERF outputs[10]
* INTERF outputs[1]
* INTERF inputs[9]
* INTERF inputs[8]
* INTERF inputs[7]
* INTERF inputs[6]
* INTERF inputs[5]
* INTERF inputs[4]
* INTERF inputs[31]
* INTERF inputs[30]
* INTERF inputs[3]
* INTERF inputs[29]
* INTERF inputs[28]
* INTERF inputs[27]
* INTERF inputs[26]
* INTERF inputs[25]
* INTERF inputs[24]
* INTERF inputs[23]
* INTERF inputs[22]
* INTERF inputs[21]
* INTERF inputs[20]
* INTERF inputs[2]
* INTERF inputs[19]
* INTERF inputs[18]
* INTERF inputs[17]
* INTERF inputs[16]
* INTERF inputs[15]
* INTERF inputs[14]
* INTERF inputs[13]
* INTERF inputs[12]
* INTERF inputs[11]
* INTERF inputs[10]
* INTERF inputs[1]
* INTERF inputs[0]

* Terminal models (aka standard cells) used througout all the hierarchy.
.include decap_w0.spi
.include nexor2_x0.spi
.include xor2_x0.spi
.include inv_x0.spi
.include tie.spi

* Non-terminal models (part of the user's design hierarchy).

.subckt expmob1_r 0 1 2 3 4 5 6 7 8 9 10 11 12 13 14 15 16 17 18 19 20 21 22 23 24 25 26 27 28 29 30 31 32 33 34 35 36 37 38 39 40 41 42 43 44 45 46 47 48 49 50 51 52 53 54 55 56 57 58 59 60 61 62 63 64
* NET     0 = vss
* NET     1 = vdd
* NET     2 = outputs[9]
* NET     3 = outputs[8]
* NET     4 = outputs[7]
* NET     5 = outputs[6]
* NET     6 = outputs[5]
* NET     7 = outputs[4]
* NET     8 = outputs[31]
* NET     9 = outputs[30]
* NET    10 = outputs[3]
* NET    11 = outputs[29]
* NET    12 = outputs[28]
* NET    13 = outputs[27]
* NET    14 = outputs[26]
* NET    15 = outputs[25]
* NET    16 = outputs[24]
* NET    17 = outputs[23]
* NET    18 = outputs[22]
* NET    19 = outputs[21]
* NET    20 = outputs[20]
* NET    21 = outputs[2]
* NET    22 = outputs[19]
* NET    23 = outputs[18]
* NET    24 = outputs[17]
* NET    25 = outputs[16]
* NET    26 = outputs[15]
* NET    27 = outputs[14]
* NET    28 = outputs[13]
* NET    29 = outputs[12]
* NET    30 = outputs[11]
* NET    31 = outputs[10]
* NET    32 = outputs[1]
* NET    33 = inputs[9]
* NET    34 = inputs[8]
* NET    35 = inputs[7]
* NET    36 = inputs[6]
* NET    37 = inputs[5]
* NET    38 = inputs[4]
* NET    39 = inputs[31]
* NET    40 = inputs[30]
* NET    41 = inputs[3]
* NET    42 = inputs[29]
* NET    43 = inputs[28]
* NET    44 = inputs[27]
* NET    45 = inputs[26]
* NET    46 = inputs[25]
* NET    47 = inputs[24]
* NET    48 = inputs[23]
* NET    49 = inputs[22]
* NET    50 = inputs[21]
* NET    51 = inputs[20]
* NET    52 = inputs[2]
* NET    53 = inputs[19]
* NET    54 = inputs[18]
* NET    55 = inputs[17]
* NET    56 = inputs[16]
* NET    57 = inputs[15]
* NET    58 = inputs[14]
* NET    59 = inputs[13]
* NET    60 = inputs[12]
* NET    61 = inputs[11]
* NET    62 = inputs[10]
* NET    63 = inputs[1]
* NET    64 = inputs[0]
* NET    65 = genblk1_3_si_outputs_7
* NET    66 = genblk1_3_si_outputs_31
* NET    67 = genblk1_3_si_outputs_3
* NET    68 = genblk1_3_si_outputs_27
* NET    69 = genblk1_3_si_outputs_23
* NET    70 = genblk1_3_si_outputs_19
* NET    71 = genblk1_3_si_outputs_15
* NET    72 = genblk1_3_si_outputs_11
* NET    73 = genblk1_2_si_outputs_7
* NET    74 = genblk1_2_si_outputs_6
* NET    75 = genblk1_2_si_outputs_5
* NET    76 = genblk1_2_si_outputs_31
* NET    77 = genblk1_2_si_outputs_30
* NET    78 = genblk1_2_si_outputs_29
* NET    79 = genblk1_2_si_outputs_23
* NET    80 = genblk1_2_si_outputs_22
* NET    81 = genblk1_2_si_outputs_21
* NET    82 = genblk1_2_si_outputs_15
* NET    83 = genblk1_2_si_outputs_14
* NET    84 = genblk1_2_si_outputs_13
* NET    85 = genblk1_1_si_outputs_9
* NET    86 = genblk1_1_si_outputs_31
* NET    87 = genblk1_1_si_outputs_30
* NET    88 = genblk1_1_si_outputs_29
* NET    89 = genblk1_1_si_outputs_28
* NET    90 = genblk1_1_si_outputs_27
* NET    91 = genblk1_1_si_outputs_26
* NET    92 = genblk1_1_si_outputs_25
* NET    93 = genblk1_1_si_outputs_15
* NET    94 = genblk1_1_si_outputs_14
* NET    95 = genblk1_1_si_outputs_13
* NET    96 = genblk1_1_si_outputs_12
* NET    97 = genblk1_1_si_outputs_11
* NET    98 = genblk1_1_si_outputs_10
* NET    99 = genblk1_1_si_inputs_31
* NET   100 = genblk1_1_si_inputs_30
* NET   101 = genblk1_1_si_inputs_29
* NET   102 = genblk1_1_si_inputs_28
* NET   103 = genblk1_1_si_inputs_27
* NET   104 = genblk1_1_si_inputs_26
* NET   105 = genblk1_1_si_inputs_25
* NET   106 = genblk1_1_si_inputs_24
* NET   107 = genblk1_1_si_inputs_23
* NET   108 = genblk1_1_si_inputs_22
* NET   109 = genblk1_1_si_inputs_21
* NET   110 = genblk1_1_si_inputs_20
* NET   111 = genblk1_1_si_inputs_19
* NET   112 = genblk1_1_si_inputs_18
* NET   113 = genblk1_1_si_inputs_17
* NET   114 = blockagenet
* NET   115 = abc_350_new_n99
* NET   116 = abc_350_new_n98
* NET   117 = abc_350_new_n96
* NET   118 = abc_350_new_n95
* NET   119 = abc_350_new_n93
* NET   120 = abc_350_new_n92
* NET   121 = abc_350_new_n91
* NET   122 = abc_350_new_n90
* NET   123 = abc_350_new_n88
* NET   124 = abc_350_new_n87
* NET   125 = abc_350_new_n86
* NET   126 = abc_350_new_n84
* NET   127 = abc_350_new_n83
* NET   128 = abc_350_new_n81
* NET   129 = abc_350_new_n79
* NET   130 = abc_350_new_n78
* NET   131 = abc_350_new_n76
* NET   132 = abc_350_new_n75
* NET   133 = abc_350_new_n73
* NET   134 = abc_350_new_n72
* NET   135 = abc_350_new_n69
* NET   136 = abc_350_new_n68
* NET   137 = abc_350_new_n66
* NET   138 = abc_350_new_n64
* NET   139 = abc_350_new_n163
* NET   140 = abc_350_new_n162
* NET   141 = abc_350_new_n161
* NET   142 = abc_350_new_n160
* NET   143 = abc_350_new_n158
* NET   144 = abc_350_new_n157
* NET   145 = abc_350_new_n156
* NET   146 = abc_350_new_n154
* NET   147 = abc_350_new_n153
* NET   148 = abc_350_new_n152
* NET   149 = abc_350_new_n150
* NET   150 = abc_350_new_n149
* NET   151 = abc_350_new_n148
* NET   152 = abc_350_new_n146
* NET   153 = abc_350_new_n145
* NET   154 = abc_350_new_n144
* NET   155 = abc_350_new_n142
* NET   156 = abc_350_new_n141
* NET   157 = abc_350_new_n140
* NET   158 = abc_350_new_n138
* NET   159 = abc_350_new_n137
* NET   160 = abc_350_new_n135
* NET   161 = abc_350_new_n134
* NET   162 = abc_350_new_n132
* NET   163 = abc_350_new_n131
* NET   164 = abc_350_new_n130
* NET   165 = abc_350_new_n129
* NET   166 = abc_350_new_n127
* NET   167 = abc_350_new_n126
* NET   168 = abc_350_new_n125
* NET   169 = abc_350_new_n123
* NET   170 = abc_350_new_n122
* NET   171 = abc_350_new_n121
* NET   172 = abc_350_new_n119
* NET   173 = abc_350_new_n118
* NET   174 = abc_350_new_n116
* NET   175 = abc_350_new_n115
* NET   176 = abc_350_new_n113
* NET   177 = abc_350_new_n111
* NET   178 = abc_350_new_n109
* NET   179 = abc_350_new_n107
* NET   180 = abc_350_new_n106
* NET   181 = abc_350_new_n105
* NET   182 = abc_350_new_n103
* NET   183 = abc_350_new_n102
* NET   184 = abc_350_new_n101

xfeed_75 1 0 decap_w0
xfeed_74 1 0 decap_w0
xfeed_73 1 0 decap_w0
xfeed_72 1 0 decap_w0
xfeed_71 1 0 decap_w0
xfeed_70 1 0 decap_w0
xsubckt_53_nexor2_x0 1 0 174 126 4 nexor2_x0
xsubckt_44_nexor2_x0 1 0 179 12 9 nexor2_x0
xsubckt_5_nexor2_x0 1 0 136 3 135 nexor2_x0
xsubckt_51_xor2_x0 1 0 35 41 175 xor2_x0
xsubckt_35_nexor2_x0 1 0 116 118 115 nexor2_x0
xsubckt_83_nexor2_x0 1 0 152 18 17 nexor2_x0
xsubckt_92_nexor2_x0 1 0 42 59 145 nexor2_x0
xsubckt_74_nexor2_x0 1 0 159 160 158 nexor2_x0
xsubckt_8_xor2_x0 1 0 38 60 134 xor2_x0
xsubckt_26_nexor2_x0 1 0 36 58 122 nexor2_x0
xsubckt_65_nexor2_x0 1 0 35 57 165 nexor2_x0
xsubckt_47_xor2_x0 1 0 41 52 177 xor2_x0
xsubckt_17_nexor2_x0 1 0 52 64 128 nexor2_x0
xsubckt_56_nexor2_x0 1 0 173 3 2 nexor2_x0
xsubckt_38_nexor2_x0 1 0 184 124 183 nexor2_x0
xsubckt_86_nexor2_x0 1 0 151 173 149 nexor2_x0
xsubckt_95_nexor2_x0 1 0 143 12 11 nexor2_x0
xsubckt_77_nexor2_x0 1 0 157 160 156 nexor2_x0
xsubckt_29_nexor2_x0 1 0 120 29 119 nexor2_x0
xsubckt_30_inv_x0 1 0 119 27 inv_x0
xsubckt_33_inv_x0 1 0 117 23 inv_x0
xsubckt_68_nexor2_x0 1 0 163 166 162 nexor2_x0
xsubckt_61_xor2_x0 1 0 37 59 168 xor2_x0
xsubckt_22_nexor2_x0 1 0 52 62 125 nexor2_x0
xsubckt_31_nexor2_x0 1 0 54 52 118 nexor2_x0
xsubckt_100_nexor2_x0 1 0 139 9 8 nexor2_x0
xsubckt_70_nexor2_x0 1 0 55 63 161 nexor2_x0
xsubckt_59_nexor2_x0 1 0 171 172 169 nexor2_x0
xsubckt_4_xor2_x0 1 0 47 56 136 xor2_x0
xsubckt_96_xor2_x0 1 0 39 48 142 xor2_x0
xsubckt_52_nexor2_x0 1 0 175 176 174 nexor2_x0
xsubckt_89_nexor2_x0 1 0 148 170 147 nexor2_x0
xsubckt_98_nexor2_x0 1 0 141 147 140 nexor2_x0
xsubckt_43_nexor2_x0 1 0 180 183 179 nexor2_x0
xsubckt_34_nexor2_x0 1 0 49 36 116 nexor2_x0
xsubckt_91_nexor2_x0 1 0 146 182 13 nexor2_x0
xsubckt_82_nexor2_x0 1 0 153 155 152 nexor2_x0
xsubckt_73_nexor2_x0 1 0 53 41 159 nexor2_x0
xsubckt_71_xor2_x0 1 0 55 63 160 xor2_x0
xsubckt_64_nexor2_x0 1 0 167 29 28 nexor2_x0
xsubckt_16_nexor2_x0 1 0 129 16 12 nexor2_x0
xsubckt_7_xor2_x0 1 0 38 64 7 xor2_x0
xsubckt_94_nexor2_x0 1 0 144 150 143 nexor2_x0
xsubckt_76_nexor2_x0 1 0 50 37 157 nexor2_x0
xsubckt_0_nexor2_x0 1 0 64 34 138 nexor2_x0
xsubckt_21_inv_x0 1 0 126 5 inv_x0
xsubckt_28_nexor2_x0 1 0 122 124 120 nexor2_x0
xsubckt_85_nexor2_x0 1 0 151 172 150 nexor2_x0
xsubckt_67_nexor2_x0 1 0 165 171 163 nexor2_x0
xsubckt_25_inv_x0 1 0 123 31 inv_x0
xsubckt_88_xor2_x0 1 0 44 53 148 xor2_x0
xfeed_0 1 0 tie
xsubckt_12_nexor2_x0 1 0 132 137 131 nexor2_x0
xsubckt_1_inv_x0 1 0 138 3 inv_x0
xsubckt_3_inv_x0 1 0 137 25 inv_x0
xfeed_1 1 0 decap_w0
xfeed_2 1 0 decap_w0
xfeed_3 1 0 decap_w0
xfeed_4 1 0 decap_w0
xfeed_5 1 0 decap_w0
xfeed_6 1 0 decap_w0
xfeed_7 1 0 decap_w0
xfeed_8 1 0 decap_w0
xfeed_9 1 0 tie
xsubckt_60_nexor2_x0 1 0 169 123 30 nexor2_x0
xsubckt_49_nexor2_x0 1 0 37 63 176 nexor2_x0
xsubckt_6_inv_x0 1 0 135 16 inv_x0
xsubckt_97_nexor2_x0 1 0 142 164 141 nexor2_x0
xsubckt_79_nexor2_x0 1 0 156 131 19 nexor2_x0
xsubckt_42_nexor2_x0 1 0 181 121 180 nexor2_x0
xsubckt_90_nexor2_x0 1 0 147 149 146 nexor2_x0
xfeed_10 1 0 tie
xfeed_11 1 0 tie
xfeed_12 1 0 tie
xfeed_13 1 0 tie
xfeed_14 1 0 tie
xfeed_15 1 0 tie
xfeed_16 1 0 tie
xfeed_17 1 0 decap_w0
xfeed_18 1 0 tie
xfeed_19 1 0 decap_w0
xsubckt_81_nexor2_x0 1 0 154 159 153 nexor2_x0
xsubckt_72_nexor2_x0 1 0 161 25 24 nexor2_x0
xsubckt_15_nexor2_x0 1 0 130 132 129 nexor2_x0
xsubckt_24_nexor2_x0 1 0 125 138 123 nexor2_x0
xfeed_20 1 0 decap_w0
xfeed_21 1 0 decap_w0
xfeed_22 1 0 tie
xfeed_23 1 0 decap_w0
xfeed_24 1 0 tie
xfeed_25 1 0 tie
xfeed_26 1 0 decap_w0
xfeed_27 1 0 tie
xfeed_28 1 0 tie
xfeed_29 1 0 decap_w0
xsubckt_63_nexor2_x0 1 0 168 173 166 nexor2_x0
xsubckt_54_nexor2_x0 1 0 63 33 173 nexor2_x0
xsubckt_84_xor2_x0 1 0 46 55 151 xor2_x0
xspare_feed_10 1 0 decap_w0
xspare_feed_11 1 0 tie
xspare_feed_12 1 0 tie
xspare_feed_13 1 0 decap_w0
xsubckt_66_xor2_x0 1 0 35 57 164 xor2_x0
xsubckt_45_nexor2_x0 1 0 63 64 178 nexor2_x0
xsubckt_93_nexor2_x0 1 0 145 157 144 nexor2_x0
xspare_feed_14 1 0 tie
xspare_feed_15 1 0 tie
xfeed_30 1 0 decap_w0
xfeed_31 1 0 tie
xfeed_32 1 0 tie
xfeed_33 1 0 tie
xfeed_34 1 0 tie
xfeed_35 1 0 tie
xfeed_36 1 0 decap_w0
xfeed_37 1 0 decap_w0
xfeed_38 1 0 decap_w0
xfeed_39 1 0 decap_w0
xsubckt_27_xor2_x0 1 0 36 58 121 xor2_x0
xsubckt_36_nexor2_x0 1 0 115 20 18 nexor2_x0
xfeed_46 1 0 tie
xfeed_45 1 0 tie
xfeed_44 1 0 tie
xsubckt_75_nexor2_x0 1 0 158 117 22 nexor2_x0
xsubckt_13_inv_x0 1 0 131 20 inv_x0
xsubckt_10_inv_x0 1 0 133 29 inv_x0
xfeed_40 1 0 decap_w0
xfeed_41 1 0 decap_w0
xfeed_42 1 0 decap_w0
xfeed_43 1 0 tie
xfeed_49 1 0 decap_w0
xfeed_48 1 0 tie
xfeed_47 1 0 tie
xsubckt_57_nexor2_x0 1 0 41 61 171 nexor2_x0
xsubckt_20_nexor2_x0 1 0 127 21 126 nexor2_x0
xsubckt_18_inv_x0 1 0 128 21 inv_x0
xspare_feed_0 1 0 tie
xspare_feed_1 1 0 tie
xspare_feed_2 1 0 tie
xspare_feed_3 1 0 tie
xspare_feed_4 1 0 decap_w0
xspare_feed_5 1 0 tie
xspare_feed_6 1 0 tie
xspare_feed_7 1 0 decap_w0
xspare_feed_8 1 0 tie
xspare_feed_9 1 0 tie
xfeed_53 1 0 decap_w0
xfeed_52 1 0 decap_w0
xfeed_51 1 0 decap_w0
xfeed_50 1 0 decap_w0
xsubckt_55_xor2_x0 1 0 63 33 172 xor2_x0
xsubckt_48_nexor2_x0 1 0 177 178 10 nexor2_x0
xsubckt_11_nexor2_x0 1 0 51 38 132 nexor2_x0
xsubckt_9_nexor2_x0 1 0 134 3 133 nexor2_x0
xfeed_59 1 0 tie
xfeed_58 1 0 decap_w0
xfeed_57 1 0 decap_w0
xfeed_56 1 0 decap_w0
xfeed_55 1 0 decap_w0
xfeed_54 1 0 decap_w0
xsubckt_50_nexor2_x0 1 0 176 7 6 nexor2_x0
xsubckt_41_xor2_x0 1 0 40 49 181 xor2_x0
xsubckt_2_nexor2_x0 1 0 56 64 137 nexor2_x0
xsubckt_39_nexor2_x0 1 0 183 135 182 nexor2_x0
xsubckt_40_inv_x0 1 0 182 14 inv_x0
xsubckt_87_nexor2_x0 1 0 150 16 15 nexor2_x0
xfeed_60 1 0 tie
xsubckt_78_nexor2_x0 1 0 157 161 155 nexor2_x0
xsubckt_69_nexor2_x0 1 0 162 119 26 nexor2_x0
xsubckt_46_inv_x0 1 0 178 32 inv_x0
xsubckt_32_nexor2_x0 1 0 118 137 117 nexor2_x0
xsubckt_37_xor2_x0 1 0 45 54 184 xor2_x0
xfeed_69 1 0 decap_w0
xfeed_68 1 0 decap_w0
xfeed_67 1 0 decap_w0
xfeed_66 1 0 decap_w0
xfeed_65 1 0 decap_w0
xfeed_64 1 0 tie
xfeed_63 1 0 tie
xfeed_62 1 0 tie
xfeed_61 1 0 tie
xsubckt_80_nexor2_x0 1 0 48 35 154 nexor2_x0
xsubckt_23_xor2_x0 1 0 52 62 124 xor2_x0
xsubckt_62_nexor2_x0 1 0 168 172 167 nexor2_x0
xsubckt_58_xor2_x0 1 0 41 61 170 xor2_x0
xsubckt_19_xor2_x0 1 0 36 38 127 xor2_x0
xsubckt_14_nexor2_x0 1 0 43 60 130 nexor2_x0
xsubckt_99_nexor2_x0 1 0 140 143 139 nexor2_x0
.ends expmob1_r
